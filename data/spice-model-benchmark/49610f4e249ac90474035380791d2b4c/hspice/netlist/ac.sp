* Translated benchmark circuit
* semantic-sha256: d6c948ccf16e517a029ef02e05919ecb87131b13cb144b12369baae54a3a4da4
.INC '/home/duhaochen/pipeline_sky130_mos/benchmark-inputs/49610f4e249ac90474035380791d2b4c/hspice.lib'
.TITLE Translated benchmark circuit
.option tnom=27
.option gmin=1e-15
.option reltol=1e-8
.option abstol=1e-12
.option chgtol=1e-15
.option method=gear

M1 drain_1 gate_1 source_1 bulk_1 __benchmark_selected_nmos l=1u w=10u
VG gate_1 0 DC 0 AC 1
VD drain_1 0 DC 1.0 AC 0
VS source_1 0 DC 0 AC 0
VB bulk_1 0 DC 0 AC 0
M2 drain_2 gate_2 0 0 __benchmark_selected_nmos l=1u w=10u
RG gate_2 gate_in2 50
RD drain_2 drain_in2 50
VGS gate_in2 0 DC 0.8 AC 0
VDS drain_in2 0 DC 1.0 AC 0
M3 drain_3 gate_3 source_3 bulk_3 __benchmark_selected_nmos l=1u w=10u
VGQ gate_3 0 DC 0 PWL(0 0 1n 0 2n 1.0 5n 1.0)
VDQ drain_3 0 DC 1.0
VSQ source_3 0 DC 0
VBQ bulk_3 0 DC 0
.PRINT AC II(VG) IR(VG) II(VD) IR(VD) II(VS) IR(VS) II(VB) IR(VB)
.PRINT AC VR(gate_1) VI(gate_1)
.PRINT AC VR(gate_in2) VI(gate_in2) VR(drain_in2) VI(drain_in2) II(VGS) IR(VGS) II(VDS) IR(VDS)
.PRINT AC VR(gate_3) VI(gate_3) II(VGQ) IR(VGQ) II(VDQ) IR(VDQ) II(VSQ) IR(VSQ) II(VBQ) IR(VBQ)
.PRINT TRAN V(gate_3) I(VGQ) I(VDQ) I(VSQ) I(VBQ)
.PARAM AST_AC_FREQUENCY=1000
.AC LIN 1 AST_AC_FREQUENCY AST_AC_FREQUENCY
.ALTER AST_CASE_0
VG gate_1 0 DC -0.8 AC 1
.TEMP 27
.PARAM AST_AC_FREQUENCY=1000
.ALTER AST_CASE_1
VG gate_1 0 DC -0.8 AC 1
.TEMP 27
.PARAM AST_AC_FREQUENCY=10000
.ALTER AST_CASE_2
VG gate_1 0 DC -0.8 AC 1
.TEMP 27
.PARAM AST_AC_FREQUENCY=100000
.ALTER AST_CASE_3
VG gate_1 0 DC -0.8 AC 1
.TEMP 27
.PARAM AST_AC_FREQUENCY=1000000
.ALTER AST_CASE_4
VG gate_1 0 DC -0.8 AC 1
VD drain_1 0 DC 1.0 AC 0
VS source_1 0 DC 0 AC 0
VB bulk_1 0 DC 0 AC 0
.TEMP 27
.PARAM AST_AC_FREQUENCY=1000000
.ALTER AST_CASE_5
VG gate_1 0 DC -0.8 AC 0
VD drain_1 0 DC 1.0 AC 1
VS source_1 0 DC 0 AC 0
VB bulk_1 0 DC 0 AC 0
.TEMP 27
.PARAM AST_AC_FREQUENCY=1000000
.ALTER AST_CASE_6
VG gate_1 0 DC -0.8 AC 0
VD drain_1 0 DC 1.0 AC 0
VS source_1 0 DC 0 AC 1
VB bulk_1 0 DC 0 AC 0
.TEMP 27
.PARAM AST_AC_FREQUENCY=1000000
.ALTER AST_CASE_7
VG gate_1 0 DC -0.8 AC 0
VD drain_1 0 DC 1.0 AC 0
VS source_1 0 DC 0 AC 0
VB bulk_1 0 DC 0 AC 1
.TEMP 27
.PARAM AST_AC_FREQUENCY=1000000
.ALTER AST_CASE_8
VG gate_1 0 DC -0.75 AC 1
VD drain_1 0 DC 1.0 AC 0
VS source_1 0 DC 0 AC 0
VB bulk_1 0 DC 0 AC 0
.TEMP 27
.PARAM AST_AC_FREQUENCY=1000
.ALTER AST_CASE_9
VG gate_1 0 DC -0.75 AC 1
VD drain_1 0 DC 1.0 AC 0
VS source_1 0 DC 0 AC 0
VB bulk_1 0 DC 0 AC 0
.TEMP 27
.PARAM AST_AC_FREQUENCY=10000
.ALTER AST_CASE_10
VG gate_1 0 DC -0.75 AC 1
VD drain_1 0 DC 1.0 AC 0
VS source_1 0 DC 0 AC 0
VB bulk_1 0 DC 0 AC 0
.TEMP 27
.PARAM AST_AC_FREQUENCY=100000
.ALTER AST_CASE_11
VG gate_1 0 DC -0.75 AC 1
VD drain_1 0 DC 1.0 AC 0
VS source_1 0 DC 0 AC 0
VB bulk_1 0 DC 0 AC 0
.TEMP 27
.PARAM AST_AC_FREQUENCY=1000000
.ALTER AST_CASE_12
VG gate_1 0 DC -0.75 AC 1
VD drain_1 0 DC 1.0 AC 0
VS source_1 0 DC 0 AC 0
VB bulk_1 0 DC 0 AC 0
.TEMP 27
.PARAM AST_AC_FREQUENCY=1000000
.ALTER AST_CASE_13
VG gate_1 0 DC -0.75 AC 0
VD drain_1 0 DC 1.0 AC 1
VS source_1 0 DC 0 AC 0
VB bulk_1 0 DC 0 AC 0
.TEMP 27
.PARAM AST_AC_FREQUENCY=1000000
.ALTER AST_CASE_14
VG gate_1 0 DC -0.75 AC 0
VD drain_1 0 DC 1.0 AC 0
VS source_1 0 DC 0 AC 1
VB bulk_1 0 DC 0 AC 0
.TEMP 27
.PARAM AST_AC_FREQUENCY=1000000
.ALTER AST_CASE_15
VG gate_1 0 DC -0.75 AC 0
VD drain_1 0 DC 1.0 AC 0
VS source_1 0 DC 0 AC 0
VB bulk_1 0 DC 0 AC 1
.TEMP 27
.PARAM AST_AC_FREQUENCY=1000000
.ALTER AST_CASE_16
VG gate_1 0 DC -0.7 AC 1
VD drain_1 0 DC 1.0 AC 0
VS source_1 0 DC 0 AC 0
VB bulk_1 0 DC 0 AC 0
.TEMP 27
.PARAM AST_AC_FREQUENCY=1000
.ALTER AST_CASE_17
VG gate_1 0 DC -0.7 AC 1
VD drain_1 0 DC 1.0 AC 0
VS source_1 0 DC 0 AC 0
VB bulk_1 0 DC 0 AC 0
.TEMP 27
.PARAM AST_AC_FREQUENCY=10000
.ALTER AST_CASE_18
VG gate_1 0 DC -0.7 AC 1
VD drain_1 0 DC 1.0 AC 0
VS source_1 0 DC 0 AC 0
VB bulk_1 0 DC 0 AC 0
.TEMP 27
.PARAM AST_AC_FREQUENCY=100000
.ALTER AST_CASE_19
VG gate_1 0 DC -0.7 AC 1
VD drain_1 0 DC 1.0 AC 0
VS source_1 0 DC 0 AC 0
VB bulk_1 0 DC 0 AC 0
.TEMP 27
.PARAM AST_AC_FREQUENCY=1000000
.ALTER AST_CASE_20
VG gate_1 0 DC -0.7 AC 1
VD drain_1 0 DC 1.0 AC 0
VS source_1 0 DC 0 AC 0
VB bulk_1 0 DC 0 AC 0
.TEMP 27
.PARAM AST_AC_FREQUENCY=1000000
.ALTER AST_CASE_21
VG gate_1 0 DC -0.7 AC 0
VD drain_1 0 DC 1.0 AC 1
VS source_1 0 DC 0 AC 0
VB bulk_1 0 DC 0 AC 0
.TEMP 27
.PARAM AST_AC_FREQUENCY=1000000
.ALTER AST_CASE_22
VG gate_1 0 DC -0.7 AC 0
VD drain_1 0 DC 1.0 AC 0
VS source_1 0 DC 0 AC 1
VB bulk_1 0 DC 0 AC 0
.TEMP 27
.PARAM AST_AC_FREQUENCY=1000000
.ALTER AST_CASE_23
VG gate_1 0 DC -0.7 AC 0
VD drain_1 0 DC 1.0 AC 0
VS source_1 0 DC 0 AC 0
VB bulk_1 0 DC 0 AC 1
.TEMP 27
.PARAM AST_AC_FREQUENCY=1000000
.ALTER AST_CASE_24
VG gate_1 0 DC -0.65 AC 1
VD drain_1 0 DC 1.0 AC 0
VS source_1 0 DC 0 AC 0
VB bulk_1 0 DC 0 AC 0
.TEMP 27
.PARAM AST_AC_FREQUENCY=1000
.ALTER AST_CASE_25
VG gate_1 0 DC -0.65 AC 1
VD drain_1 0 DC 1.0 AC 0
VS source_1 0 DC 0 AC 0
VB bulk_1 0 DC 0 AC 0
.TEMP 27
.PARAM AST_AC_FREQUENCY=10000
.ALTER AST_CASE_26
VG gate_1 0 DC -0.65 AC 1
VD drain_1 0 DC 1.0 AC 0
VS source_1 0 DC 0 AC 0
VB bulk_1 0 DC 0 AC 0
.TEMP 27
.PARAM AST_AC_FREQUENCY=100000
.ALTER AST_CASE_27
VG gate_1 0 DC -0.65 AC 1
VD drain_1 0 DC 1.0 AC 0
VS source_1 0 DC 0 AC 0
VB bulk_1 0 DC 0 AC 0
.TEMP 27
.PARAM AST_AC_FREQUENCY=1000000
.ALTER AST_CASE_28
VG gate_1 0 DC -0.65 AC 1
VD drain_1 0 DC 1.0 AC 0
VS source_1 0 DC 0 AC 0
VB bulk_1 0 DC 0 AC 0
.TEMP 27
.PARAM AST_AC_FREQUENCY=1000000
.ALTER AST_CASE_29
VG gate_1 0 DC -0.65 AC 0
VD drain_1 0 DC 1.0 AC 1
VS source_1 0 DC 0 AC 0
VB bulk_1 0 DC 0 AC 0
.TEMP 27
.PARAM AST_AC_FREQUENCY=1000000
.ALTER AST_CASE_30
VG gate_1 0 DC -0.65 AC 0
VD drain_1 0 DC 1.0 AC 0
VS source_1 0 DC 0 AC 1
VB bulk_1 0 DC 0 AC 0
.TEMP 27
.PARAM AST_AC_FREQUENCY=1000000
.ALTER AST_CASE_31
VG gate_1 0 DC -0.65 AC 0
VD drain_1 0 DC 1.0 AC 0
VS source_1 0 DC 0 AC 0
VB bulk_1 0 DC 0 AC 1
.TEMP 27
.PARAM AST_AC_FREQUENCY=1000000
.ALTER AST_CASE_32
VG gate_1 0 DC -0.6 AC 1
VD drain_1 0 DC 1.0 AC 0
VS source_1 0 DC 0 AC 0
VB bulk_1 0 DC 0 AC 0
.TEMP 27
.PARAM AST_AC_FREQUENCY=1000
.ALTER AST_CASE_33
VG gate_1 0 DC -0.6 AC 1
VD drain_1 0 DC 1.0 AC 0
VS source_1 0 DC 0 AC 0
VB bulk_1 0 DC 0 AC 0
.TEMP 27
.PARAM AST_AC_FREQUENCY=10000
.ALTER AST_CASE_34
VG gate_1 0 DC -0.6 AC 1
VD drain_1 0 DC 1.0 AC 0
VS source_1 0 DC 0 AC 0
VB bulk_1 0 DC 0 AC 0
.TEMP 27
.PARAM AST_AC_FREQUENCY=100000
.ALTER AST_CASE_35
VG gate_1 0 DC -0.6 AC 1
VD drain_1 0 DC 1.0 AC 0
VS source_1 0 DC 0 AC 0
VB bulk_1 0 DC 0 AC 0
.TEMP 27
.PARAM AST_AC_FREQUENCY=1000000
.ALTER AST_CASE_36
VG gate_1 0 DC -0.6 AC 1
VD drain_1 0 DC 1.0 AC 0
VS source_1 0 DC 0 AC 0
VB bulk_1 0 DC 0 AC 0
.TEMP 27
.PARAM AST_AC_FREQUENCY=1000000
.ALTER AST_CASE_37
VG gate_1 0 DC -0.6 AC 0
VD drain_1 0 DC 1.0 AC 1
VS source_1 0 DC 0 AC 0
VB bulk_1 0 DC 0 AC 0
.TEMP 27
.PARAM AST_AC_FREQUENCY=1000000
.ALTER AST_CASE_38
VG gate_1 0 DC -0.6 AC 0
VD drain_1 0 DC 1.0 AC 0
VS source_1 0 DC 0 AC 1
VB bulk_1 0 DC 0 AC 0
.TEMP 27
.PARAM AST_AC_FREQUENCY=1000000
.ALTER AST_CASE_39
VG gate_1 0 DC -0.6 AC 0
VD drain_1 0 DC 1.0 AC 0
VS source_1 0 DC 0 AC 0
VB bulk_1 0 DC 0 AC 1
.TEMP 27
.PARAM AST_AC_FREQUENCY=1000000
.ALTER AST_CASE_40
VG gate_1 0 DC -0.55 AC 1
VD drain_1 0 DC 1.0 AC 0
VS source_1 0 DC 0 AC 0
VB bulk_1 0 DC 0 AC 0
.TEMP 27
.PARAM AST_AC_FREQUENCY=1000
.ALTER AST_CASE_41
VG gate_1 0 DC -0.55 AC 1
VD drain_1 0 DC 1.0 AC 0
VS source_1 0 DC 0 AC 0
VB bulk_1 0 DC 0 AC 0
.TEMP 27
.PARAM AST_AC_FREQUENCY=10000
.ALTER AST_CASE_42
VG gate_1 0 DC -0.55 AC 1
VD drain_1 0 DC 1.0 AC 0
VS source_1 0 DC 0 AC 0
VB bulk_1 0 DC 0 AC 0
.TEMP 27
.PARAM AST_AC_FREQUENCY=100000
.ALTER AST_CASE_43
VG gate_1 0 DC -0.55 AC 1
VD drain_1 0 DC 1.0 AC 0
VS source_1 0 DC 0 AC 0
VB bulk_1 0 DC 0 AC 0
.TEMP 27
.PARAM AST_AC_FREQUENCY=1000000
.ALTER AST_CASE_44
VG gate_1 0 DC -0.55 AC 1
VD drain_1 0 DC 1.0 AC 0
VS source_1 0 DC 0 AC 0
VB bulk_1 0 DC 0 AC 0
.TEMP 27
.PARAM AST_AC_FREQUENCY=1000000
.ALTER AST_CASE_45
VG gate_1 0 DC -0.55 AC 0
VD drain_1 0 DC 1.0 AC 1
VS source_1 0 DC 0 AC 0
VB bulk_1 0 DC 0 AC 0
.TEMP 27
.PARAM AST_AC_FREQUENCY=1000000
.ALTER AST_CASE_46
VG gate_1 0 DC -0.55 AC 0
VD drain_1 0 DC 1.0 AC 0
VS source_1 0 DC 0 AC 1
VB bulk_1 0 DC 0 AC 0
.TEMP 27
.PARAM AST_AC_FREQUENCY=1000000
.ALTER AST_CASE_47
VG gate_1 0 DC -0.55 AC 0
VD drain_1 0 DC 1.0 AC 0
VS source_1 0 DC 0 AC 0
VB bulk_1 0 DC 0 AC 1
.TEMP 27
.PARAM AST_AC_FREQUENCY=1000000
.ALTER AST_CASE_48
VG gate_1 0 DC -0.5 AC 1
VD drain_1 0 DC 1.0 AC 0
VS source_1 0 DC 0 AC 0
VB bulk_1 0 DC 0 AC 0
.TEMP 27
.PARAM AST_AC_FREQUENCY=1000
.ALTER AST_CASE_49
VG gate_1 0 DC -0.5 AC 1
VD drain_1 0 DC 1.0 AC 0
VS source_1 0 DC 0 AC 0
VB bulk_1 0 DC 0 AC 0
.TEMP 27
.PARAM AST_AC_FREQUENCY=10000
.ALTER AST_CASE_50
VG gate_1 0 DC -0.5 AC 1
VD drain_1 0 DC 1.0 AC 0
VS source_1 0 DC 0 AC 0
VB bulk_1 0 DC 0 AC 0
.TEMP 27
.PARAM AST_AC_FREQUENCY=100000
.ALTER AST_CASE_51
VG gate_1 0 DC -0.5 AC 1
VD drain_1 0 DC 1.0 AC 0
VS source_1 0 DC 0 AC 0
VB bulk_1 0 DC 0 AC 0
.TEMP 27
.PARAM AST_AC_FREQUENCY=1000000
.ALTER AST_CASE_52
VG gate_1 0 DC -0.5 AC 1
VD drain_1 0 DC 1.0 AC 0
VS source_1 0 DC 0 AC 0
VB bulk_1 0 DC 0 AC 0
.TEMP 27
.PARAM AST_AC_FREQUENCY=1000000
.ALTER AST_CASE_53
VG gate_1 0 DC -0.5 AC 0
VD drain_1 0 DC 1.0 AC 1
VS source_1 0 DC 0 AC 0
VB bulk_1 0 DC 0 AC 0
.TEMP 27
.PARAM AST_AC_FREQUENCY=1000000
.ALTER AST_CASE_54
VG gate_1 0 DC -0.5 AC 0
VD drain_1 0 DC 1.0 AC 0
VS source_1 0 DC 0 AC 1
VB bulk_1 0 DC 0 AC 0
.TEMP 27
.PARAM AST_AC_FREQUENCY=1000000
.ALTER AST_CASE_55
VG gate_1 0 DC -0.5 AC 0
VD drain_1 0 DC 1.0 AC 0
VS source_1 0 DC 0 AC 0
VB bulk_1 0 DC 0 AC 1
.TEMP 27
.PARAM AST_AC_FREQUENCY=1000000
.ALTER AST_CASE_56
VG gate_1 0 DC -0.45 AC 1
VD drain_1 0 DC 1.0 AC 0
VS source_1 0 DC 0 AC 0
VB bulk_1 0 DC 0 AC 0
.TEMP 27
.PARAM AST_AC_FREQUENCY=1000
.ALTER AST_CASE_57
VG gate_1 0 DC -0.45 AC 1
VD drain_1 0 DC 1.0 AC 0
VS source_1 0 DC 0 AC 0
VB bulk_1 0 DC 0 AC 0
.TEMP 27
.PARAM AST_AC_FREQUENCY=10000
.ALTER AST_CASE_58
VG gate_1 0 DC -0.45 AC 1
VD drain_1 0 DC 1.0 AC 0
VS source_1 0 DC 0 AC 0
VB bulk_1 0 DC 0 AC 0
.TEMP 27
.PARAM AST_AC_FREQUENCY=100000
.ALTER AST_CASE_59
VG gate_1 0 DC -0.45 AC 1
VD drain_1 0 DC 1.0 AC 0
VS source_1 0 DC 0 AC 0
VB bulk_1 0 DC 0 AC 0
.TEMP 27
.PARAM AST_AC_FREQUENCY=1000000
.ALTER AST_CASE_60
VG gate_1 0 DC -0.45 AC 1
VD drain_1 0 DC 1.0 AC 0
VS source_1 0 DC 0 AC 0
VB bulk_1 0 DC 0 AC 0
.TEMP 27
.PARAM AST_AC_FREQUENCY=1000000
.ALTER AST_CASE_61
VG gate_1 0 DC -0.45 AC 0
VD drain_1 0 DC 1.0 AC 1
VS source_1 0 DC 0 AC 0
VB bulk_1 0 DC 0 AC 0
.TEMP 27
.PARAM AST_AC_FREQUENCY=1000000
.ALTER AST_CASE_62
VG gate_1 0 DC -0.45 AC 0
VD drain_1 0 DC 1.0 AC 0
VS source_1 0 DC 0 AC 1
VB bulk_1 0 DC 0 AC 0
.TEMP 27
.PARAM AST_AC_FREQUENCY=1000000
.ALTER AST_CASE_63
VG gate_1 0 DC -0.45 AC 0
VD drain_1 0 DC 1.0 AC 0
VS source_1 0 DC 0 AC 0
VB bulk_1 0 DC 0 AC 1
.TEMP 27
.PARAM AST_AC_FREQUENCY=1000000
.ALTER AST_CASE_64
VG gate_1 0 DC -0.4 AC 1
VD drain_1 0 DC 1.0 AC 0
VS source_1 0 DC 0 AC 0
VB bulk_1 0 DC 0 AC 0
.TEMP 27
.PARAM AST_AC_FREQUENCY=1000
.ALTER AST_CASE_65
VG gate_1 0 DC -0.4 AC 1
VD drain_1 0 DC 1.0 AC 0
VS source_1 0 DC 0 AC 0
VB bulk_1 0 DC 0 AC 0
.TEMP 27
.PARAM AST_AC_FREQUENCY=10000
.ALTER AST_CASE_66
VG gate_1 0 DC -0.4 AC 1
VD drain_1 0 DC 1.0 AC 0
VS source_1 0 DC 0 AC 0
VB bulk_1 0 DC 0 AC 0
.TEMP 27
.PARAM AST_AC_FREQUENCY=100000
.ALTER AST_CASE_67
VG gate_1 0 DC -0.4 AC 1
VD drain_1 0 DC 1.0 AC 0
VS source_1 0 DC 0 AC 0
VB bulk_1 0 DC 0 AC 0
.TEMP 27
.PARAM AST_AC_FREQUENCY=1000000
.ALTER AST_CASE_68
VG gate_1 0 DC -0.4 AC 1
VD drain_1 0 DC 1.0 AC 0
VS source_1 0 DC 0 AC 0
VB bulk_1 0 DC 0 AC 0
.TEMP 27
.PARAM AST_AC_FREQUENCY=1000000
.ALTER AST_CASE_69
VG gate_1 0 DC -0.4 AC 0
VD drain_1 0 DC 1.0 AC 1
VS source_1 0 DC 0 AC 0
VB bulk_1 0 DC 0 AC 0
.TEMP 27
.PARAM AST_AC_FREQUENCY=1000000
.ALTER AST_CASE_70
VG gate_1 0 DC -0.4 AC 0
VD drain_1 0 DC 1.0 AC 0
VS source_1 0 DC 0 AC 1
VB bulk_1 0 DC 0 AC 0
.TEMP 27
.PARAM AST_AC_FREQUENCY=1000000
.ALTER AST_CASE_71
VG gate_1 0 DC -0.4 AC 0
VD drain_1 0 DC 1.0 AC 0
VS source_1 0 DC 0 AC 0
VB bulk_1 0 DC 0 AC 1
.TEMP 27
.PARAM AST_AC_FREQUENCY=1000000
.ALTER AST_CASE_72
VG gate_1 0 DC -0.35 AC 1
VD drain_1 0 DC 1.0 AC 0
VS source_1 0 DC 0 AC 0
VB bulk_1 0 DC 0 AC 0
.TEMP 27
.PARAM AST_AC_FREQUENCY=1000
.ALTER AST_CASE_73
VG gate_1 0 DC -0.35 AC 1
VD drain_1 0 DC 1.0 AC 0
VS source_1 0 DC 0 AC 0
VB bulk_1 0 DC 0 AC 0
.TEMP 27
.PARAM AST_AC_FREQUENCY=10000
.ALTER AST_CASE_74
VG gate_1 0 DC -0.35 AC 1
VD drain_1 0 DC 1.0 AC 0
VS source_1 0 DC 0 AC 0
VB bulk_1 0 DC 0 AC 0
.TEMP 27
.PARAM AST_AC_FREQUENCY=100000
.ALTER AST_CASE_75
VG gate_1 0 DC -0.35 AC 1
VD drain_1 0 DC 1.0 AC 0
VS source_1 0 DC 0 AC 0
VB bulk_1 0 DC 0 AC 0
.TEMP 27
.PARAM AST_AC_FREQUENCY=1000000
.ALTER AST_CASE_76
VG gate_1 0 DC -0.35 AC 1
VD drain_1 0 DC 1.0 AC 0
VS source_1 0 DC 0 AC 0
VB bulk_1 0 DC 0 AC 0
.TEMP 27
.PARAM AST_AC_FREQUENCY=1000000
.ALTER AST_CASE_77
VG gate_1 0 DC -0.35 AC 0
VD drain_1 0 DC 1.0 AC 1
VS source_1 0 DC 0 AC 0
VB bulk_1 0 DC 0 AC 0
.TEMP 27
.PARAM AST_AC_FREQUENCY=1000000
.ALTER AST_CASE_78
VG gate_1 0 DC -0.35 AC 0
VD drain_1 0 DC 1.0 AC 0
VS source_1 0 DC 0 AC 1
VB bulk_1 0 DC 0 AC 0
.TEMP 27
.PARAM AST_AC_FREQUENCY=1000000
.ALTER AST_CASE_79
VG gate_1 0 DC -0.35 AC 0
VD drain_1 0 DC 1.0 AC 0
VS source_1 0 DC 0 AC 0
VB bulk_1 0 DC 0 AC 1
.TEMP 27
.PARAM AST_AC_FREQUENCY=1000000
.ALTER AST_CASE_80
VG gate_1 0 DC -0.3 AC 1
VD drain_1 0 DC 1.0 AC 0
VS source_1 0 DC 0 AC 0
VB bulk_1 0 DC 0 AC 0
.TEMP 27
.PARAM AST_AC_FREQUENCY=1000
.ALTER AST_CASE_81
VG gate_1 0 DC -0.3 AC 1
VD drain_1 0 DC 1.0 AC 0
VS source_1 0 DC 0 AC 0
VB bulk_1 0 DC 0 AC 0
.TEMP 27
.PARAM AST_AC_FREQUENCY=10000
.ALTER AST_CASE_82
VG gate_1 0 DC -0.3 AC 1
VD drain_1 0 DC 1.0 AC 0
VS source_1 0 DC 0 AC 0
VB bulk_1 0 DC 0 AC 0
.TEMP 27
.PARAM AST_AC_FREQUENCY=100000
.ALTER AST_CASE_83
VG gate_1 0 DC -0.3 AC 1
VD drain_1 0 DC 1.0 AC 0
VS source_1 0 DC 0 AC 0
VB bulk_1 0 DC 0 AC 0
.TEMP 27
.PARAM AST_AC_FREQUENCY=1000000
.ALTER AST_CASE_84
VG gate_1 0 DC -0.3 AC 1
VD drain_1 0 DC 1.0 AC 0
VS source_1 0 DC 0 AC 0
VB bulk_1 0 DC 0 AC 0
.TEMP 27
.PARAM AST_AC_FREQUENCY=1000000
.ALTER AST_CASE_85
VG gate_1 0 DC -0.3 AC 0
VD drain_1 0 DC 1.0 AC 1
VS source_1 0 DC 0 AC 0
VB bulk_1 0 DC 0 AC 0
.TEMP 27
.PARAM AST_AC_FREQUENCY=1000000
.ALTER AST_CASE_86
VG gate_1 0 DC -0.3 AC 0
VD drain_1 0 DC 1.0 AC 0
VS source_1 0 DC 0 AC 1
VB bulk_1 0 DC 0 AC 0
.TEMP 27
.PARAM AST_AC_FREQUENCY=1000000
.ALTER AST_CASE_87
VG gate_1 0 DC -0.3 AC 0
VD drain_1 0 DC 1.0 AC 0
VS source_1 0 DC 0 AC 0
VB bulk_1 0 DC 0 AC 1
.TEMP 27
.PARAM AST_AC_FREQUENCY=1000000
.ALTER AST_CASE_88
VG gate_1 0 DC -0.25 AC 1
VD drain_1 0 DC 1.0 AC 0
VS source_1 0 DC 0 AC 0
VB bulk_1 0 DC 0 AC 0
.TEMP 27
.PARAM AST_AC_FREQUENCY=1000
.ALTER AST_CASE_89
VG gate_1 0 DC -0.25 AC 1
VD drain_1 0 DC 1.0 AC 0
VS source_1 0 DC 0 AC 0
VB bulk_1 0 DC 0 AC 0
.TEMP 27
.PARAM AST_AC_FREQUENCY=10000
.ALTER AST_CASE_90
VG gate_1 0 DC -0.25 AC 1
VD drain_1 0 DC 1.0 AC 0
VS source_1 0 DC 0 AC 0
VB bulk_1 0 DC 0 AC 0
.TEMP 27
.PARAM AST_AC_FREQUENCY=100000
.ALTER AST_CASE_91
VG gate_1 0 DC -0.25 AC 1
VD drain_1 0 DC 1.0 AC 0
VS source_1 0 DC 0 AC 0
VB bulk_1 0 DC 0 AC 0
.TEMP 27
.PARAM AST_AC_FREQUENCY=1000000
.ALTER AST_CASE_92
VG gate_1 0 DC -0.25 AC 1
VD drain_1 0 DC 1.0 AC 0
VS source_1 0 DC 0 AC 0
VB bulk_1 0 DC 0 AC 0
.TEMP 27
.PARAM AST_AC_FREQUENCY=1000000
.ALTER AST_CASE_93
VG gate_1 0 DC -0.25 AC 0
VD drain_1 0 DC 1.0 AC 1
VS source_1 0 DC 0 AC 0
VB bulk_1 0 DC 0 AC 0
.TEMP 27
.PARAM AST_AC_FREQUENCY=1000000
.ALTER AST_CASE_94
VG gate_1 0 DC -0.25 AC 0
VD drain_1 0 DC 1.0 AC 0
VS source_1 0 DC 0 AC 1
VB bulk_1 0 DC 0 AC 0
.TEMP 27
.PARAM AST_AC_FREQUENCY=1000000
.ALTER AST_CASE_95
VG gate_1 0 DC -0.25 AC 0
VD drain_1 0 DC 1.0 AC 0
VS source_1 0 DC 0 AC 0
VB bulk_1 0 DC 0 AC 1
.TEMP 27
.PARAM AST_AC_FREQUENCY=1000000
.ALTER AST_CASE_96
VG gate_1 0 DC -0.2 AC 1
VD drain_1 0 DC 1.0 AC 0
VS source_1 0 DC 0 AC 0
VB bulk_1 0 DC 0 AC 0
.TEMP 27
.PARAM AST_AC_FREQUENCY=1000
.ALTER AST_CASE_97
VG gate_1 0 DC -0.2 AC 1
VD drain_1 0 DC 1.0 AC 0
VS source_1 0 DC 0 AC 0
VB bulk_1 0 DC 0 AC 0
.TEMP 27
.PARAM AST_AC_FREQUENCY=10000
.ALTER AST_CASE_98
VG gate_1 0 DC -0.2 AC 1
VD drain_1 0 DC 1.0 AC 0
VS source_1 0 DC 0 AC 0
VB bulk_1 0 DC 0 AC 0
.TEMP 27
.PARAM AST_AC_FREQUENCY=100000
.ALTER AST_CASE_99
VG gate_1 0 DC -0.2 AC 1
VD drain_1 0 DC 1.0 AC 0
VS source_1 0 DC 0 AC 0
VB bulk_1 0 DC 0 AC 0
.TEMP 27
.PARAM AST_AC_FREQUENCY=1000000
.ALTER AST_CASE_100
VG gate_1 0 DC -0.2 AC 1
VD drain_1 0 DC 1.0 AC 0
VS source_1 0 DC 0 AC 0
VB bulk_1 0 DC 0 AC 0
.TEMP 27
.PARAM AST_AC_FREQUENCY=1000000
.ALTER AST_CASE_101
VG gate_1 0 DC -0.2 AC 0
VD drain_1 0 DC 1.0 AC 1
VS source_1 0 DC 0 AC 0
VB bulk_1 0 DC 0 AC 0
.TEMP 27
.PARAM AST_AC_FREQUENCY=1000000
.ALTER AST_CASE_102
VG gate_1 0 DC -0.2 AC 0
VD drain_1 0 DC 1.0 AC 0
VS source_1 0 DC 0 AC 1
VB bulk_1 0 DC 0 AC 0
.TEMP 27
.PARAM AST_AC_FREQUENCY=1000000
.ALTER AST_CASE_103
VG gate_1 0 DC -0.2 AC 0
VD drain_1 0 DC 1.0 AC 0
VS source_1 0 DC 0 AC 0
VB bulk_1 0 DC 0 AC 1
.TEMP 27
.PARAM AST_AC_FREQUENCY=1000000
.ALTER AST_CASE_104
VG gate_1 0 DC -0.15 AC 1
VD drain_1 0 DC 1.0 AC 0
VS source_1 0 DC 0 AC 0
VB bulk_1 0 DC 0 AC 0
.TEMP 27
.PARAM AST_AC_FREQUENCY=1000
.ALTER AST_CASE_105
VG gate_1 0 DC -0.15 AC 1
VD drain_1 0 DC 1.0 AC 0
VS source_1 0 DC 0 AC 0
VB bulk_1 0 DC 0 AC 0
.TEMP 27
.PARAM AST_AC_FREQUENCY=10000
.ALTER AST_CASE_106
VG gate_1 0 DC -0.15 AC 1
VD drain_1 0 DC 1.0 AC 0
VS source_1 0 DC 0 AC 0
VB bulk_1 0 DC 0 AC 0
.TEMP 27
.PARAM AST_AC_FREQUENCY=100000
.ALTER AST_CASE_107
VG gate_1 0 DC -0.15 AC 1
VD drain_1 0 DC 1.0 AC 0
VS source_1 0 DC 0 AC 0
VB bulk_1 0 DC 0 AC 0
.TEMP 27
.PARAM AST_AC_FREQUENCY=1000000
.ALTER AST_CASE_108
VG gate_1 0 DC -0.15 AC 1
VD drain_1 0 DC 1.0 AC 0
VS source_1 0 DC 0 AC 0
VB bulk_1 0 DC 0 AC 0
.TEMP 27
.PARAM AST_AC_FREQUENCY=1000000
.ALTER AST_CASE_109
VG gate_1 0 DC -0.15 AC 0
VD drain_1 0 DC 1.0 AC 1
VS source_1 0 DC 0 AC 0
VB bulk_1 0 DC 0 AC 0
.TEMP 27
.PARAM AST_AC_FREQUENCY=1000000
.ALTER AST_CASE_110
VG gate_1 0 DC -0.15 AC 0
VD drain_1 0 DC 1.0 AC 0
VS source_1 0 DC 0 AC 1
VB bulk_1 0 DC 0 AC 0
.TEMP 27
.PARAM AST_AC_FREQUENCY=1000000
.ALTER AST_CASE_111
VG gate_1 0 DC -0.15 AC 0
VD drain_1 0 DC 1.0 AC 0
VS source_1 0 DC 0 AC 0
VB bulk_1 0 DC 0 AC 1
.TEMP 27
.PARAM AST_AC_FREQUENCY=1000000
.ALTER AST_CASE_112
VG gate_1 0 DC -0.1 AC 1
VD drain_1 0 DC 1.0 AC 0
VS source_1 0 DC 0 AC 0
VB bulk_1 0 DC 0 AC 0
.TEMP 27
.PARAM AST_AC_FREQUENCY=1000
.ALTER AST_CASE_113
VG gate_1 0 DC -0.1 AC 1
VD drain_1 0 DC 1.0 AC 0
VS source_1 0 DC 0 AC 0
VB bulk_1 0 DC 0 AC 0
.TEMP 27
.PARAM AST_AC_FREQUENCY=10000
.ALTER AST_CASE_114
VG gate_1 0 DC -0.1 AC 1
VD drain_1 0 DC 1.0 AC 0
VS source_1 0 DC 0 AC 0
VB bulk_1 0 DC 0 AC 0
.TEMP 27
.PARAM AST_AC_FREQUENCY=100000
.ALTER AST_CASE_115
VG gate_1 0 DC -0.1 AC 1
VD drain_1 0 DC 1.0 AC 0
VS source_1 0 DC 0 AC 0
VB bulk_1 0 DC 0 AC 0
.TEMP 27
.PARAM AST_AC_FREQUENCY=1000000
.ALTER AST_CASE_116
VG gate_1 0 DC -0.1 AC 1
VD drain_1 0 DC 1.0 AC 0
VS source_1 0 DC 0 AC 0
VB bulk_1 0 DC 0 AC 0
.TEMP 27
.PARAM AST_AC_FREQUENCY=1000000
.ALTER AST_CASE_117
VG gate_1 0 DC -0.1 AC 0
VD drain_1 0 DC 1.0 AC 1
VS source_1 0 DC 0 AC 0
VB bulk_1 0 DC 0 AC 0
.TEMP 27
.PARAM AST_AC_FREQUENCY=1000000
.ALTER AST_CASE_118
VG gate_1 0 DC -0.1 AC 0
VD drain_1 0 DC 1.0 AC 0
VS source_1 0 DC 0 AC 1
VB bulk_1 0 DC 0 AC 0
.TEMP 27
.PARAM AST_AC_FREQUENCY=1000000
.ALTER AST_CASE_119
VG gate_1 0 DC -0.1 AC 0
VD drain_1 0 DC 1.0 AC 0
VS source_1 0 DC 0 AC 0
VB bulk_1 0 DC 0 AC 1
.TEMP 27
.PARAM AST_AC_FREQUENCY=1000000
.ALTER AST_CASE_120
VG gate_1 0 DC -0.05 AC 1
VD drain_1 0 DC 1.0 AC 0
VS source_1 0 DC 0 AC 0
VB bulk_1 0 DC 0 AC 0
.TEMP 27
.PARAM AST_AC_FREQUENCY=1000
.ALTER AST_CASE_121
VG gate_1 0 DC -0.05 AC 1
VD drain_1 0 DC 1.0 AC 0
VS source_1 0 DC 0 AC 0
VB bulk_1 0 DC 0 AC 0
.TEMP 27
.PARAM AST_AC_FREQUENCY=10000
.ALTER AST_CASE_122
VG gate_1 0 DC -0.05 AC 1
VD drain_1 0 DC 1.0 AC 0
VS source_1 0 DC 0 AC 0
VB bulk_1 0 DC 0 AC 0
.TEMP 27
.PARAM AST_AC_FREQUENCY=100000
.ALTER AST_CASE_123
VG gate_1 0 DC -0.05 AC 1
VD drain_1 0 DC 1.0 AC 0
VS source_1 0 DC 0 AC 0
VB bulk_1 0 DC 0 AC 0
.TEMP 27
.PARAM AST_AC_FREQUENCY=1000000
.ALTER AST_CASE_124
VG gate_1 0 DC -0.05 AC 1
VD drain_1 0 DC 1.0 AC 0
VS source_1 0 DC 0 AC 0
VB bulk_1 0 DC 0 AC 0
.TEMP 27
.PARAM AST_AC_FREQUENCY=1000000
.ALTER AST_CASE_125
VG gate_1 0 DC -0.05 AC 0
VD drain_1 0 DC 1.0 AC 1
VS source_1 0 DC 0 AC 0
VB bulk_1 0 DC 0 AC 0
.TEMP 27
.PARAM AST_AC_FREQUENCY=1000000
.ALTER AST_CASE_126
VG gate_1 0 DC -0.05 AC 0
VD drain_1 0 DC 1.0 AC 0
VS source_1 0 DC 0 AC 1
VB bulk_1 0 DC 0 AC 0
.TEMP 27
.PARAM AST_AC_FREQUENCY=1000000
.ALTER AST_CASE_127
VG gate_1 0 DC -0.05 AC 0
VD drain_1 0 DC 1.0 AC 0
VS source_1 0 DC 0 AC 0
VB bulk_1 0 DC 0 AC 1
.TEMP 27
.PARAM AST_AC_FREQUENCY=1000000
.ALTER AST_CASE_128
VG gate_1 0 DC 0 AC 1
VD drain_1 0 DC 1.0 AC 0
VS source_1 0 DC 0 AC 0
VB bulk_1 0 DC 0 AC 0
.TEMP 27
.PARAM AST_AC_FREQUENCY=1000
.ALTER AST_CASE_129
VG gate_1 0 DC 0 AC 1
VD drain_1 0 DC 1.0 AC 0
VS source_1 0 DC 0 AC 0
VB bulk_1 0 DC 0 AC 0
.TEMP 27
.PARAM AST_AC_FREQUENCY=10000
.ALTER AST_CASE_130
VG gate_1 0 DC 0 AC 1
VD drain_1 0 DC 1.0 AC 0
VS source_1 0 DC 0 AC 0
VB bulk_1 0 DC 0 AC 0
.TEMP 27
.PARAM AST_AC_FREQUENCY=100000
.ALTER AST_CASE_131
VG gate_1 0 DC 0 AC 1
VD drain_1 0 DC 1.0 AC 0
VS source_1 0 DC 0 AC 0
VB bulk_1 0 DC 0 AC 0
.TEMP 27
.PARAM AST_AC_FREQUENCY=1000000
.ALTER AST_CASE_132
VG gate_1 0 DC 0 AC 1
VD drain_1 0 DC 1.0 AC 0
VS source_1 0 DC 0 AC 0
VB bulk_1 0 DC 0 AC 0
.TEMP 27
.PARAM AST_AC_FREQUENCY=1000000
.ALTER AST_CASE_133
VG gate_1 0 DC 0 AC 0
VD drain_1 0 DC 1.0 AC 1
VS source_1 0 DC 0 AC 0
VB bulk_1 0 DC 0 AC 0
.TEMP 27
.PARAM AST_AC_FREQUENCY=1000000
.ALTER AST_CASE_134
VG gate_1 0 DC 0 AC 0
VD drain_1 0 DC 1.0 AC 0
VS source_1 0 DC 0 AC 1
VB bulk_1 0 DC 0 AC 0
.TEMP 27
.PARAM AST_AC_FREQUENCY=1000000
.ALTER AST_CASE_135
VG gate_1 0 DC 0 AC 0
VD drain_1 0 DC 1.0 AC 0
VS source_1 0 DC 0 AC 0
VB bulk_1 0 DC 0 AC 1
.TEMP 27
.PARAM AST_AC_FREQUENCY=1000000
.ALTER AST_CASE_136
VG gate_1 0 DC 0.05 AC 1
VD drain_1 0 DC 1.0 AC 0
VS source_1 0 DC 0 AC 0
VB bulk_1 0 DC 0 AC 0
.TEMP 27
.PARAM AST_AC_FREQUENCY=1000
.ALTER AST_CASE_137
VG gate_1 0 DC 0.05 AC 1
VD drain_1 0 DC 1.0 AC 0
VS source_1 0 DC 0 AC 0
VB bulk_1 0 DC 0 AC 0
.TEMP 27
.PARAM AST_AC_FREQUENCY=10000
.ALTER AST_CASE_138
VG gate_1 0 DC 0.05 AC 1
VD drain_1 0 DC 1.0 AC 0
VS source_1 0 DC 0 AC 0
VB bulk_1 0 DC 0 AC 0
.TEMP 27
.PARAM AST_AC_FREQUENCY=100000
.ALTER AST_CASE_139
VG gate_1 0 DC 0.05 AC 1
VD drain_1 0 DC 1.0 AC 0
VS source_1 0 DC 0 AC 0
VB bulk_1 0 DC 0 AC 0
.TEMP 27
.PARAM AST_AC_FREQUENCY=1000000
.ALTER AST_CASE_140
VG gate_1 0 DC 0.05 AC 1
VD drain_1 0 DC 1.0 AC 0
VS source_1 0 DC 0 AC 0
VB bulk_1 0 DC 0 AC 0
.TEMP 27
.PARAM AST_AC_FREQUENCY=1000000
.ALTER AST_CASE_141
VG gate_1 0 DC 0.05 AC 0
VD drain_1 0 DC 1.0 AC 1
VS source_1 0 DC 0 AC 0
VB bulk_1 0 DC 0 AC 0
.TEMP 27
.PARAM AST_AC_FREQUENCY=1000000
.ALTER AST_CASE_142
VG gate_1 0 DC 0.05 AC 0
VD drain_1 0 DC 1.0 AC 0
VS source_1 0 DC 0 AC 1
VB bulk_1 0 DC 0 AC 0
.TEMP 27
.PARAM AST_AC_FREQUENCY=1000000
.ALTER AST_CASE_143
VG gate_1 0 DC 0.05 AC 0
VD drain_1 0 DC 1.0 AC 0
VS source_1 0 DC 0 AC 0
VB bulk_1 0 DC 0 AC 1
.TEMP 27
.PARAM AST_AC_FREQUENCY=1000000
.ALTER AST_CASE_144
VG gate_1 0 DC 0.1 AC 1
VD drain_1 0 DC 1.0 AC 0
VS source_1 0 DC 0 AC 0
VB bulk_1 0 DC 0 AC 0
.TEMP 27
.PARAM AST_AC_FREQUENCY=1000
.ALTER AST_CASE_145
VG gate_1 0 DC 0.1 AC 1
VD drain_1 0 DC 1.0 AC 0
VS source_1 0 DC 0 AC 0
VB bulk_1 0 DC 0 AC 0
.TEMP 27
.PARAM AST_AC_FREQUENCY=10000
.ALTER AST_CASE_146
VG gate_1 0 DC 0.1 AC 1
VD drain_1 0 DC 1.0 AC 0
VS source_1 0 DC 0 AC 0
VB bulk_1 0 DC 0 AC 0
.TEMP 27
.PARAM AST_AC_FREQUENCY=100000
.ALTER AST_CASE_147
VG gate_1 0 DC 0.1 AC 1
VD drain_1 0 DC 1.0 AC 0
VS source_1 0 DC 0 AC 0
VB bulk_1 0 DC 0 AC 0
.TEMP 27
.PARAM AST_AC_FREQUENCY=1000000
.ALTER AST_CASE_148
VG gate_1 0 DC 0.1 AC 1
VD drain_1 0 DC 1.0 AC 0
VS source_1 0 DC 0 AC 0
VB bulk_1 0 DC 0 AC 0
.TEMP 27
.PARAM AST_AC_FREQUENCY=1000000
.ALTER AST_CASE_149
VG gate_1 0 DC 0.1 AC 0
VD drain_1 0 DC 1.0 AC 1
VS source_1 0 DC 0 AC 0
VB bulk_1 0 DC 0 AC 0
.TEMP 27
.PARAM AST_AC_FREQUENCY=1000000
.ALTER AST_CASE_150
VG gate_1 0 DC 0.1 AC 0
VD drain_1 0 DC 1.0 AC 0
VS source_1 0 DC 0 AC 1
VB bulk_1 0 DC 0 AC 0
.TEMP 27
.PARAM AST_AC_FREQUENCY=1000000
.ALTER AST_CASE_151
VG gate_1 0 DC 0.1 AC 0
VD drain_1 0 DC 1.0 AC 0
VS source_1 0 DC 0 AC 0
VB bulk_1 0 DC 0 AC 1
.TEMP 27
.PARAM AST_AC_FREQUENCY=1000000
.ALTER AST_CASE_152
VG gate_1 0 DC 0.15 AC 1
VD drain_1 0 DC 1.0 AC 0
VS source_1 0 DC 0 AC 0
VB bulk_1 0 DC 0 AC 0
.TEMP 27
.PARAM AST_AC_FREQUENCY=1000
.ALTER AST_CASE_153
VG gate_1 0 DC 0.15 AC 1
VD drain_1 0 DC 1.0 AC 0
VS source_1 0 DC 0 AC 0
VB bulk_1 0 DC 0 AC 0
.TEMP 27
.PARAM AST_AC_FREQUENCY=10000
.ALTER AST_CASE_154
VG gate_1 0 DC 0.15 AC 1
VD drain_1 0 DC 1.0 AC 0
VS source_1 0 DC 0 AC 0
VB bulk_1 0 DC 0 AC 0
.TEMP 27
.PARAM AST_AC_FREQUENCY=100000
.ALTER AST_CASE_155
VG gate_1 0 DC 0.15 AC 1
VD drain_1 0 DC 1.0 AC 0
VS source_1 0 DC 0 AC 0
VB bulk_1 0 DC 0 AC 0
.TEMP 27
.PARAM AST_AC_FREQUENCY=1000000
.ALTER AST_CASE_156
VG gate_1 0 DC 0.15 AC 1
VD drain_1 0 DC 1.0 AC 0
VS source_1 0 DC 0 AC 0
VB bulk_1 0 DC 0 AC 0
.TEMP 27
.PARAM AST_AC_FREQUENCY=1000000
.ALTER AST_CASE_157
VG gate_1 0 DC 0.15 AC 0
VD drain_1 0 DC 1.0 AC 1
VS source_1 0 DC 0 AC 0
VB bulk_1 0 DC 0 AC 0
.TEMP 27
.PARAM AST_AC_FREQUENCY=1000000
.ALTER AST_CASE_158
VG gate_1 0 DC 0.15 AC 0
VD drain_1 0 DC 1.0 AC 0
VS source_1 0 DC 0 AC 1
VB bulk_1 0 DC 0 AC 0
.TEMP 27
.PARAM AST_AC_FREQUENCY=1000000
.ALTER AST_CASE_159
VG gate_1 0 DC 0.15 AC 0
VD drain_1 0 DC 1.0 AC 0
VS source_1 0 DC 0 AC 0
VB bulk_1 0 DC 0 AC 1
.TEMP 27
.PARAM AST_AC_FREQUENCY=1000000
.ALTER AST_CASE_160
VG gate_1 0 DC 0.2 AC 1
VD drain_1 0 DC 1.0 AC 0
VS source_1 0 DC 0 AC 0
VB bulk_1 0 DC 0 AC 0
.TEMP 27
.PARAM AST_AC_FREQUENCY=1000
.ALTER AST_CASE_161
VG gate_1 0 DC 0.2 AC 1
VD drain_1 0 DC 1.0 AC 0
VS source_1 0 DC 0 AC 0
VB bulk_1 0 DC 0 AC 0
.TEMP 27
.PARAM AST_AC_FREQUENCY=10000
.ALTER AST_CASE_162
VG gate_1 0 DC 0.2 AC 1
VD drain_1 0 DC 1.0 AC 0
VS source_1 0 DC 0 AC 0
VB bulk_1 0 DC 0 AC 0
.TEMP 27
.PARAM AST_AC_FREQUENCY=100000
.ALTER AST_CASE_163
VG gate_1 0 DC 0.2 AC 1
VD drain_1 0 DC 1.0 AC 0
VS source_1 0 DC 0 AC 0
VB bulk_1 0 DC 0 AC 0
.TEMP 27
.PARAM AST_AC_FREQUENCY=1000000
.ALTER AST_CASE_164
VG gate_1 0 DC 0.2 AC 1
VD drain_1 0 DC 1.0 AC 0
VS source_1 0 DC 0 AC 0
VB bulk_1 0 DC 0 AC 0
.TEMP 27
.PARAM AST_AC_FREQUENCY=1000000
.ALTER AST_CASE_165
VG gate_1 0 DC 0.2 AC 0
VD drain_1 0 DC 1.0 AC 1
VS source_1 0 DC 0 AC 0
VB bulk_1 0 DC 0 AC 0
.TEMP 27
.PARAM AST_AC_FREQUENCY=1000000
.ALTER AST_CASE_166
VG gate_1 0 DC 0.2 AC 0
VD drain_1 0 DC 1.0 AC 0
VS source_1 0 DC 0 AC 1
VB bulk_1 0 DC 0 AC 0
.TEMP 27
.PARAM AST_AC_FREQUENCY=1000000
.ALTER AST_CASE_167
VG gate_1 0 DC 0.2 AC 0
VD drain_1 0 DC 1.0 AC 0
VS source_1 0 DC 0 AC 0
VB bulk_1 0 DC 0 AC 1
.TEMP 27
.PARAM AST_AC_FREQUENCY=1000000
.ALTER AST_CASE_168
VG gate_1 0 DC 0.25 AC 1
VD drain_1 0 DC 1.0 AC 0
VS source_1 0 DC 0 AC 0
VB bulk_1 0 DC 0 AC 0
.TEMP 27
.PARAM AST_AC_FREQUENCY=1000
.ALTER AST_CASE_169
VG gate_1 0 DC 0.25 AC 1
VD drain_1 0 DC 1.0 AC 0
VS source_1 0 DC 0 AC 0
VB bulk_1 0 DC 0 AC 0
.TEMP 27
.PARAM AST_AC_FREQUENCY=10000
.ALTER AST_CASE_170
VG gate_1 0 DC 0.25 AC 1
VD drain_1 0 DC 1.0 AC 0
VS source_1 0 DC 0 AC 0
VB bulk_1 0 DC 0 AC 0
.TEMP 27
.PARAM AST_AC_FREQUENCY=100000
.ALTER AST_CASE_171
VG gate_1 0 DC 0.25 AC 1
VD drain_1 0 DC 1.0 AC 0
VS source_1 0 DC 0 AC 0
VB bulk_1 0 DC 0 AC 0
.TEMP 27
.PARAM AST_AC_FREQUENCY=1000000
.ALTER AST_CASE_172
VG gate_1 0 DC 0.25 AC 1
VD drain_1 0 DC 1.0 AC 0
VS source_1 0 DC 0 AC 0
VB bulk_1 0 DC 0 AC 0
.TEMP 27
.PARAM AST_AC_FREQUENCY=1000000
.ALTER AST_CASE_173
VG gate_1 0 DC 0.25 AC 0
VD drain_1 0 DC 1.0 AC 1
VS source_1 0 DC 0 AC 0
VB bulk_1 0 DC 0 AC 0
.TEMP 27
.PARAM AST_AC_FREQUENCY=1000000
.ALTER AST_CASE_174
VG gate_1 0 DC 0.25 AC 0
VD drain_1 0 DC 1.0 AC 0
VS source_1 0 DC 0 AC 1
VB bulk_1 0 DC 0 AC 0
.TEMP 27
.PARAM AST_AC_FREQUENCY=1000000
.ALTER AST_CASE_175
VG gate_1 0 DC 0.25 AC 0
VD drain_1 0 DC 1.0 AC 0
VS source_1 0 DC 0 AC 0
VB bulk_1 0 DC 0 AC 1
.TEMP 27
.PARAM AST_AC_FREQUENCY=1000000
.ALTER AST_CASE_176
VG gate_1 0 DC 0.3 AC 1
VD drain_1 0 DC 1.0 AC 0
VS source_1 0 DC 0 AC 0
VB bulk_1 0 DC 0 AC 0
.TEMP 27
.PARAM AST_AC_FREQUENCY=1000
.ALTER AST_CASE_177
VG gate_1 0 DC 0.3 AC 1
VD drain_1 0 DC 1.0 AC 0
VS source_1 0 DC 0 AC 0
VB bulk_1 0 DC 0 AC 0
.TEMP 27
.PARAM AST_AC_FREQUENCY=10000
.ALTER AST_CASE_178
VG gate_1 0 DC 0.3 AC 1
VD drain_1 0 DC 1.0 AC 0
VS source_1 0 DC 0 AC 0
VB bulk_1 0 DC 0 AC 0
.TEMP 27
.PARAM AST_AC_FREQUENCY=100000
.ALTER AST_CASE_179
VG gate_1 0 DC 0.3 AC 1
VD drain_1 0 DC 1.0 AC 0
VS source_1 0 DC 0 AC 0
VB bulk_1 0 DC 0 AC 0
.TEMP 27
.PARAM AST_AC_FREQUENCY=1000000
.ALTER AST_CASE_180
VG gate_1 0 DC 0.3 AC 1
VD drain_1 0 DC 1.0 AC 0
VS source_1 0 DC 0 AC 0
VB bulk_1 0 DC 0 AC 0
.TEMP 27
.PARAM AST_AC_FREQUENCY=1000000
.ALTER AST_CASE_181
VG gate_1 0 DC 0.3 AC 0
VD drain_1 0 DC 1.0 AC 1
VS source_1 0 DC 0 AC 0
VB bulk_1 0 DC 0 AC 0
.TEMP 27
.PARAM AST_AC_FREQUENCY=1000000
.ALTER AST_CASE_182
VG gate_1 0 DC 0.3 AC 0
VD drain_1 0 DC 1.0 AC 0
VS source_1 0 DC 0 AC 1
VB bulk_1 0 DC 0 AC 0
.TEMP 27
.PARAM AST_AC_FREQUENCY=1000000
.ALTER AST_CASE_183
VG gate_1 0 DC 0.3 AC 0
VD drain_1 0 DC 1.0 AC 0
VS source_1 0 DC 0 AC 0
VB bulk_1 0 DC 0 AC 1
.TEMP 27
.PARAM AST_AC_FREQUENCY=1000000
.ALTER AST_CASE_184
VG gate_1 0 DC 0.35 AC 1
VD drain_1 0 DC 1.0 AC 0
VS source_1 0 DC 0 AC 0
VB bulk_1 0 DC 0 AC 0
.TEMP 27
.PARAM AST_AC_FREQUENCY=1000
.ALTER AST_CASE_185
VG gate_1 0 DC 0.35 AC 1
VD drain_1 0 DC 1.0 AC 0
VS source_1 0 DC 0 AC 0
VB bulk_1 0 DC 0 AC 0
.TEMP 27
.PARAM AST_AC_FREQUENCY=10000
.ALTER AST_CASE_186
VG gate_1 0 DC 0.35 AC 1
VD drain_1 0 DC 1.0 AC 0
VS source_1 0 DC 0 AC 0
VB bulk_1 0 DC 0 AC 0
.TEMP 27
.PARAM AST_AC_FREQUENCY=100000
.ALTER AST_CASE_187
VG gate_1 0 DC 0.35 AC 1
VD drain_1 0 DC 1.0 AC 0
VS source_1 0 DC 0 AC 0
VB bulk_1 0 DC 0 AC 0
.TEMP 27
.PARAM AST_AC_FREQUENCY=1000000
.ALTER AST_CASE_188
VG gate_1 0 DC 0.35 AC 1
VD drain_1 0 DC 1.0 AC 0
VS source_1 0 DC 0 AC 0
VB bulk_1 0 DC 0 AC 0
.TEMP 27
.PARAM AST_AC_FREQUENCY=1000000
.ALTER AST_CASE_189
VG gate_1 0 DC 0.35 AC 0
VD drain_1 0 DC 1.0 AC 1
VS source_1 0 DC 0 AC 0
VB bulk_1 0 DC 0 AC 0
.TEMP 27
.PARAM AST_AC_FREQUENCY=1000000
.ALTER AST_CASE_190
VG gate_1 0 DC 0.35 AC 0
VD drain_1 0 DC 1.0 AC 0
VS source_1 0 DC 0 AC 1
VB bulk_1 0 DC 0 AC 0
.TEMP 27
.PARAM AST_AC_FREQUENCY=1000000
.ALTER AST_CASE_191
VG gate_1 0 DC 0.35 AC 0
VD drain_1 0 DC 1.0 AC 0
VS source_1 0 DC 0 AC 0
VB bulk_1 0 DC 0 AC 1
.TEMP 27
.PARAM AST_AC_FREQUENCY=1000000
.ALTER AST_CASE_192
VG gate_1 0 DC 0.4 AC 1
VD drain_1 0 DC 1.0 AC 0
VS source_1 0 DC 0 AC 0
VB bulk_1 0 DC 0 AC 0
.TEMP 27
.PARAM AST_AC_FREQUENCY=1000
.ALTER AST_CASE_193
VG gate_1 0 DC 0.4 AC 1
VD drain_1 0 DC 1.0 AC 0
VS source_1 0 DC 0 AC 0
VB bulk_1 0 DC 0 AC 0
.TEMP 27
.PARAM AST_AC_FREQUENCY=10000
.ALTER AST_CASE_194
VG gate_1 0 DC 0.4 AC 1
VD drain_1 0 DC 1.0 AC 0
VS source_1 0 DC 0 AC 0
VB bulk_1 0 DC 0 AC 0
.TEMP 27
.PARAM AST_AC_FREQUENCY=100000
.ALTER AST_CASE_195
VG gate_1 0 DC 0.4 AC 1
VD drain_1 0 DC 1.0 AC 0
VS source_1 0 DC 0 AC 0
VB bulk_1 0 DC 0 AC 0
.TEMP 27
.PARAM AST_AC_FREQUENCY=1000000
.ALTER AST_CASE_196
VG gate_1 0 DC 0.4 AC 1
VD drain_1 0 DC 1.0 AC 0
VS source_1 0 DC 0 AC 0
VB bulk_1 0 DC 0 AC 0
.TEMP 27
.PARAM AST_AC_FREQUENCY=1000000
.ALTER AST_CASE_197
VG gate_1 0 DC 0.4 AC 0
VD drain_1 0 DC 1.0 AC 1
VS source_1 0 DC 0 AC 0
VB bulk_1 0 DC 0 AC 0
.TEMP 27
.PARAM AST_AC_FREQUENCY=1000000
.ALTER AST_CASE_198
VG gate_1 0 DC 0.4 AC 0
VD drain_1 0 DC 1.0 AC 0
VS source_1 0 DC 0 AC 1
VB bulk_1 0 DC 0 AC 0
.TEMP 27
.PARAM AST_AC_FREQUENCY=1000000
.ALTER AST_CASE_199
VG gate_1 0 DC 0.4 AC 0
VD drain_1 0 DC 1.0 AC 0
VS source_1 0 DC 0 AC 0
VB bulk_1 0 DC 0 AC 1
.TEMP 27
.PARAM AST_AC_FREQUENCY=1000000
.ALTER AST_CASE_200
VG gate_1 0 DC 0.45 AC 1
VD drain_1 0 DC 1.0 AC 0
VS source_1 0 DC 0 AC 0
VB bulk_1 0 DC 0 AC 0
.TEMP 27
.PARAM AST_AC_FREQUENCY=1000
.ALTER AST_CASE_201
VG gate_1 0 DC 0.45 AC 1
VD drain_1 0 DC 1.0 AC 0
VS source_1 0 DC 0 AC 0
VB bulk_1 0 DC 0 AC 0
.TEMP 27
.PARAM AST_AC_FREQUENCY=10000
.ALTER AST_CASE_202
VG gate_1 0 DC 0.45 AC 1
VD drain_1 0 DC 1.0 AC 0
VS source_1 0 DC 0 AC 0
VB bulk_1 0 DC 0 AC 0
.TEMP 27
.PARAM AST_AC_FREQUENCY=100000
.ALTER AST_CASE_203
VG gate_1 0 DC 0.45 AC 1
VD drain_1 0 DC 1.0 AC 0
VS source_1 0 DC 0 AC 0
VB bulk_1 0 DC 0 AC 0
.TEMP 27
.PARAM AST_AC_FREQUENCY=1000000
.ALTER AST_CASE_204
VG gate_1 0 DC 0.45 AC 1
VD drain_1 0 DC 1.0 AC 0
VS source_1 0 DC 0 AC 0
VB bulk_1 0 DC 0 AC 0
.TEMP 27
.PARAM AST_AC_FREQUENCY=1000000
.ALTER AST_CASE_205
VG gate_1 0 DC 0.45 AC 0
VD drain_1 0 DC 1.0 AC 1
VS source_1 0 DC 0 AC 0
VB bulk_1 0 DC 0 AC 0
.TEMP 27
.PARAM AST_AC_FREQUENCY=1000000
.ALTER AST_CASE_206
VG gate_1 0 DC 0.45 AC 0
VD drain_1 0 DC 1.0 AC 0
VS source_1 0 DC 0 AC 1
VB bulk_1 0 DC 0 AC 0
.TEMP 27
.PARAM AST_AC_FREQUENCY=1000000
.ALTER AST_CASE_207
VG gate_1 0 DC 0.45 AC 0
VD drain_1 0 DC 1.0 AC 0
VS source_1 0 DC 0 AC 0
VB bulk_1 0 DC 0 AC 1
.TEMP 27
.PARAM AST_AC_FREQUENCY=1000000
.ALTER AST_CASE_208
VG gate_1 0 DC 0.5 AC 1
VD drain_1 0 DC 1.0 AC 0
VS source_1 0 DC 0 AC 0
VB bulk_1 0 DC 0 AC 0
.TEMP 27
.PARAM AST_AC_FREQUENCY=1000
.ALTER AST_CASE_209
VG gate_1 0 DC 0.5 AC 1
VD drain_1 0 DC 1.0 AC 0
VS source_1 0 DC 0 AC 0
VB bulk_1 0 DC 0 AC 0
.TEMP 27
.PARAM AST_AC_FREQUENCY=10000
.ALTER AST_CASE_210
VG gate_1 0 DC 0.5 AC 1
VD drain_1 0 DC 1.0 AC 0
VS source_1 0 DC 0 AC 0
VB bulk_1 0 DC 0 AC 0
.TEMP 27
.PARAM AST_AC_FREQUENCY=100000
.ALTER AST_CASE_211
VG gate_1 0 DC 0.5 AC 1
VD drain_1 0 DC 1.0 AC 0
VS source_1 0 DC 0 AC 0
VB bulk_1 0 DC 0 AC 0
.TEMP 27
.PARAM AST_AC_FREQUENCY=1000000
.ALTER AST_CASE_212
VG gate_1 0 DC 0.5 AC 1
VD drain_1 0 DC 1.0 AC 0
VS source_1 0 DC 0 AC 0
VB bulk_1 0 DC 0 AC 0
.TEMP 27
.PARAM AST_AC_FREQUENCY=1000000
.ALTER AST_CASE_213
VG gate_1 0 DC 0.5 AC 0
VD drain_1 0 DC 1.0 AC 1
VS source_1 0 DC 0 AC 0
VB bulk_1 0 DC 0 AC 0
.TEMP 27
.PARAM AST_AC_FREQUENCY=1000000
.ALTER AST_CASE_214
VG gate_1 0 DC 0.5 AC 0
VD drain_1 0 DC 1.0 AC 0
VS source_1 0 DC 0 AC 1
VB bulk_1 0 DC 0 AC 0
.TEMP 27
.PARAM AST_AC_FREQUENCY=1000000
.ALTER AST_CASE_215
VG gate_1 0 DC 0.5 AC 0
VD drain_1 0 DC 1.0 AC 0
VS source_1 0 DC 0 AC 0
VB bulk_1 0 DC 0 AC 1
.TEMP 27
.PARAM AST_AC_FREQUENCY=1000000
.ALTER AST_CASE_216
VG gate_1 0 DC 0.55 AC 1
VD drain_1 0 DC 1.0 AC 0
VS source_1 0 DC 0 AC 0
VB bulk_1 0 DC 0 AC 0
.TEMP 27
.PARAM AST_AC_FREQUENCY=1000
.ALTER AST_CASE_217
VG gate_1 0 DC 0.55 AC 1
VD drain_1 0 DC 1.0 AC 0
VS source_1 0 DC 0 AC 0
VB bulk_1 0 DC 0 AC 0
.TEMP 27
.PARAM AST_AC_FREQUENCY=10000
.ALTER AST_CASE_218
VG gate_1 0 DC 0.55 AC 1
VD drain_1 0 DC 1.0 AC 0
VS source_1 0 DC 0 AC 0
VB bulk_1 0 DC 0 AC 0
.TEMP 27
.PARAM AST_AC_FREQUENCY=100000
.ALTER AST_CASE_219
VG gate_1 0 DC 0.55 AC 1
VD drain_1 0 DC 1.0 AC 0
VS source_1 0 DC 0 AC 0
VB bulk_1 0 DC 0 AC 0
.TEMP 27
.PARAM AST_AC_FREQUENCY=1000000
.ALTER AST_CASE_220
VG gate_1 0 DC 0.55 AC 1
VD drain_1 0 DC 1.0 AC 0
VS source_1 0 DC 0 AC 0
VB bulk_1 0 DC 0 AC 0
.TEMP 27
.PARAM AST_AC_FREQUENCY=1000000
.ALTER AST_CASE_221
VG gate_1 0 DC 0.55 AC 0
VD drain_1 0 DC 1.0 AC 1
VS source_1 0 DC 0 AC 0
VB bulk_1 0 DC 0 AC 0
.TEMP 27
.PARAM AST_AC_FREQUENCY=1000000
.ALTER AST_CASE_222
VG gate_1 0 DC 0.55 AC 0
VD drain_1 0 DC 1.0 AC 0
VS source_1 0 DC 0 AC 1
VB bulk_1 0 DC 0 AC 0
.TEMP 27
.PARAM AST_AC_FREQUENCY=1000000
.ALTER AST_CASE_223
VG gate_1 0 DC 0.55 AC 0
VD drain_1 0 DC 1.0 AC 0
VS source_1 0 DC 0 AC 0
VB bulk_1 0 DC 0 AC 1
.TEMP 27
.PARAM AST_AC_FREQUENCY=1000000
.ALTER AST_CASE_224
VG gate_1 0 DC 0.6 AC 1
VD drain_1 0 DC 1.0 AC 0
VS source_1 0 DC 0 AC 0
VB bulk_1 0 DC 0 AC 0
.TEMP 27
.PARAM AST_AC_FREQUENCY=1000
.ALTER AST_CASE_225
VG gate_1 0 DC 0.6 AC 1
VD drain_1 0 DC 1.0 AC 0
VS source_1 0 DC 0 AC 0
VB bulk_1 0 DC 0 AC 0
.TEMP 27
.PARAM AST_AC_FREQUENCY=10000
.ALTER AST_CASE_226
VG gate_1 0 DC 0.6 AC 1
VD drain_1 0 DC 1.0 AC 0
VS source_1 0 DC 0 AC 0
VB bulk_1 0 DC 0 AC 0
.TEMP 27
.PARAM AST_AC_FREQUENCY=100000
.ALTER AST_CASE_227
VG gate_1 0 DC 0.6 AC 1
VD drain_1 0 DC 1.0 AC 0
VS source_1 0 DC 0 AC 0
VB bulk_1 0 DC 0 AC 0
.TEMP 27
.PARAM AST_AC_FREQUENCY=1000000
.ALTER AST_CASE_228
VG gate_1 0 DC 0.6 AC 1
VD drain_1 0 DC 1.0 AC 0
VS source_1 0 DC 0 AC 0
VB bulk_1 0 DC 0 AC 0
.TEMP 27
.PARAM AST_AC_FREQUENCY=1000000
.ALTER AST_CASE_229
VG gate_1 0 DC 0.6 AC 0
VD drain_1 0 DC 1.0 AC 1
VS source_1 0 DC 0 AC 0
VB bulk_1 0 DC 0 AC 0
.TEMP 27
.PARAM AST_AC_FREQUENCY=1000000
.ALTER AST_CASE_230
VG gate_1 0 DC 0.6 AC 0
VD drain_1 0 DC 1.0 AC 0
VS source_1 0 DC 0 AC 1
VB bulk_1 0 DC 0 AC 0
.TEMP 27
.PARAM AST_AC_FREQUENCY=1000000
.ALTER AST_CASE_231
VG gate_1 0 DC 0.6 AC 0
VD drain_1 0 DC 1.0 AC 0
VS source_1 0 DC 0 AC 0
VB bulk_1 0 DC 0 AC 1
.TEMP 27
.PARAM AST_AC_FREQUENCY=1000000
.ALTER AST_CASE_232
VG gate_1 0 DC 0.65 AC 1
VD drain_1 0 DC 1.0 AC 0
VS source_1 0 DC 0 AC 0
VB bulk_1 0 DC 0 AC 0
.TEMP 27
.PARAM AST_AC_FREQUENCY=1000
.ALTER AST_CASE_233
VG gate_1 0 DC 0.65 AC 1
VD drain_1 0 DC 1.0 AC 0
VS source_1 0 DC 0 AC 0
VB bulk_1 0 DC 0 AC 0
.TEMP 27
.PARAM AST_AC_FREQUENCY=10000
.ALTER AST_CASE_234
VG gate_1 0 DC 0.65 AC 1
VD drain_1 0 DC 1.0 AC 0
VS source_1 0 DC 0 AC 0
VB bulk_1 0 DC 0 AC 0
.TEMP 27
.PARAM AST_AC_FREQUENCY=100000
.ALTER AST_CASE_235
VG gate_1 0 DC 0.65 AC 1
VD drain_1 0 DC 1.0 AC 0
VS source_1 0 DC 0 AC 0
VB bulk_1 0 DC 0 AC 0
.TEMP 27
.PARAM AST_AC_FREQUENCY=1000000
.ALTER AST_CASE_236
VG gate_1 0 DC 0.65 AC 1
VD drain_1 0 DC 1.0 AC 0
VS source_1 0 DC 0 AC 0
VB bulk_1 0 DC 0 AC 0
.TEMP 27
.PARAM AST_AC_FREQUENCY=1000000
.ALTER AST_CASE_237
VG gate_1 0 DC 0.65 AC 0
VD drain_1 0 DC 1.0 AC 1
VS source_1 0 DC 0 AC 0
VB bulk_1 0 DC 0 AC 0
.TEMP 27
.PARAM AST_AC_FREQUENCY=1000000
.ALTER AST_CASE_238
VG gate_1 0 DC 0.65 AC 0
VD drain_1 0 DC 1.0 AC 0
VS source_1 0 DC 0 AC 1
VB bulk_1 0 DC 0 AC 0
.TEMP 27
.PARAM AST_AC_FREQUENCY=1000000
.ALTER AST_CASE_239
VG gate_1 0 DC 0.65 AC 0
VD drain_1 0 DC 1.0 AC 0
VS source_1 0 DC 0 AC 0
VB bulk_1 0 DC 0 AC 1
.TEMP 27
.PARAM AST_AC_FREQUENCY=1000000
.ALTER AST_CASE_240
VG gate_1 0 DC 0.7 AC 1
VD drain_1 0 DC 1.0 AC 0
VS source_1 0 DC 0 AC 0
VB bulk_1 0 DC 0 AC 0
.TEMP 27
.PARAM AST_AC_FREQUENCY=1000
.ALTER AST_CASE_241
VG gate_1 0 DC 0.7 AC 1
VD drain_1 0 DC 1.0 AC 0
VS source_1 0 DC 0 AC 0
VB bulk_1 0 DC 0 AC 0
.TEMP 27
.PARAM AST_AC_FREQUENCY=10000
.ALTER AST_CASE_242
VG gate_1 0 DC 0.7 AC 1
VD drain_1 0 DC 1.0 AC 0
VS source_1 0 DC 0 AC 0
VB bulk_1 0 DC 0 AC 0
.TEMP 27
.PARAM AST_AC_FREQUENCY=100000
.ALTER AST_CASE_243
VG gate_1 0 DC 0.7 AC 1
VD drain_1 0 DC 1.0 AC 0
VS source_1 0 DC 0 AC 0
VB bulk_1 0 DC 0 AC 0
.TEMP 27
.PARAM AST_AC_FREQUENCY=1000000
.ALTER AST_CASE_244
VG gate_1 0 DC 0.7 AC 1
VD drain_1 0 DC 1.0 AC 0
VS source_1 0 DC 0 AC 0
VB bulk_1 0 DC 0 AC 0
.TEMP 27
.PARAM AST_AC_FREQUENCY=1000000
.ALTER AST_CASE_245
VG gate_1 0 DC 0.7 AC 0
VD drain_1 0 DC 1.0 AC 1
VS source_1 0 DC 0 AC 0
VB bulk_1 0 DC 0 AC 0
.TEMP 27
.PARAM AST_AC_FREQUENCY=1000000
.ALTER AST_CASE_246
VG gate_1 0 DC 0.7 AC 0
VD drain_1 0 DC 1.0 AC 0
VS source_1 0 DC 0 AC 1
VB bulk_1 0 DC 0 AC 0
.TEMP 27
.PARAM AST_AC_FREQUENCY=1000000
.ALTER AST_CASE_247
VG gate_1 0 DC 0.7 AC 0
VD drain_1 0 DC 1.0 AC 0
VS source_1 0 DC 0 AC 0
VB bulk_1 0 DC 0 AC 1
.TEMP 27
.PARAM AST_AC_FREQUENCY=1000000
.ALTER AST_CASE_248
VG gate_1 0 DC 0.75 AC 1
VD drain_1 0 DC 1.0 AC 0
VS source_1 0 DC 0 AC 0
VB bulk_1 0 DC 0 AC 0
.TEMP 27
.PARAM AST_AC_FREQUENCY=1000
.ALTER AST_CASE_249
VG gate_1 0 DC 0.75 AC 1
VD drain_1 0 DC 1.0 AC 0
VS source_1 0 DC 0 AC 0
VB bulk_1 0 DC 0 AC 0
.TEMP 27
.PARAM AST_AC_FREQUENCY=10000
.ALTER AST_CASE_250
VG gate_1 0 DC 0.75 AC 1
VD drain_1 0 DC 1.0 AC 0
VS source_1 0 DC 0 AC 0
VB bulk_1 0 DC 0 AC 0
.TEMP 27
.PARAM AST_AC_FREQUENCY=100000
.ALTER AST_CASE_251
VG gate_1 0 DC 0.75 AC 1
VD drain_1 0 DC 1.0 AC 0
VS source_1 0 DC 0 AC 0
VB bulk_1 0 DC 0 AC 0
.TEMP 27
.PARAM AST_AC_FREQUENCY=1000000
.ALTER AST_CASE_252
VG gate_1 0 DC 0.75 AC 1
VD drain_1 0 DC 1.0 AC 0
VS source_1 0 DC 0 AC 0
VB bulk_1 0 DC 0 AC 0
.TEMP 27
.PARAM AST_AC_FREQUENCY=1000000
.ALTER AST_CASE_253
VG gate_1 0 DC 0.75 AC 0
VD drain_1 0 DC 1.0 AC 1
VS source_1 0 DC 0 AC 0
VB bulk_1 0 DC 0 AC 0
.TEMP 27
.PARAM AST_AC_FREQUENCY=1000000
.ALTER AST_CASE_254
VG gate_1 0 DC 0.75 AC 0
VD drain_1 0 DC 1.0 AC 0
VS source_1 0 DC 0 AC 1
VB bulk_1 0 DC 0 AC 0
.TEMP 27
.PARAM AST_AC_FREQUENCY=1000000
.ALTER AST_CASE_255
VG gate_1 0 DC 0.75 AC 0
VD drain_1 0 DC 1.0 AC 0
VS source_1 0 DC 0 AC 0
VB bulk_1 0 DC 0 AC 1
.TEMP 27
.PARAM AST_AC_FREQUENCY=1000000
.ALTER AST_CASE_256
VG gate_1 0 DC 0.8 AC 1
VD drain_1 0 DC 1.0 AC 0
VS source_1 0 DC 0 AC 0
VB bulk_1 0 DC 0 AC 0
.TEMP 27
.PARAM AST_AC_FREQUENCY=1000
.ALTER AST_CASE_257
VG gate_1 0 DC 0.8 AC 1
VD drain_1 0 DC 1.0 AC 0
VS source_1 0 DC 0 AC 0
VB bulk_1 0 DC 0 AC 0
.TEMP 27
.PARAM AST_AC_FREQUENCY=10000
.ALTER AST_CASE_258
VG gate_1 0 DC 0.8 AC 1
VD drain_1 0 DC 1.0 AC 0
VS source_1 0 DC 0 AC 0
VB bulk_1 0 DC 0 AC 0
.TEMP 27
.PARAM AST_AC_FREQUENCY=100000
.ALTER AST_CASE_259
VG gate_1 0 DC 0.8 AC 1
VD drain_1 0 DC 1.0 AC 0
VS source_1 0 DC 0 AC 0
VB bulk_1 0 DC 0 AC 0
.TEMP 27
.PARAM AST_AC_FREQUENCY=1000000
.ALTER AST_CASE_260
VG gate_1 0 DC 0.8 AC 1
VD drain_1 0 DC 1.0 AC 0
VS source_1 0 DC 0 AC 0
VB bulk_1 0 DC 0 AC 0
.TEMP 27
.PARAM AST_AC_FREQUENCY=1000000
.ALTER AST_CASE_261
VG gate_1 0 DC 0.8 AC 0
VD drain_1 0 DC 1.0 AC 1
VS source_1 0 DC 0 AC 0
VB bulk_1 0 DC 0 AC 0
.TEMP 27
.PARAM AST_AC_FREQUENCY=1000000
.ALTER AST_CASE_262
VG gate_1 0 DC 0.8 AC 0
VD drain_1 0 DC 1.0 AC 0
VS source_1 0 DC 0 AC 1
VB bulk_1 0 DC 0 AC 0
.TEMP 27
.PARAM AST_AC_FREQUENCY=1000000
.ALTER AST_CASE_263
VG gate_1 0 DC 0.8 AC 0
VD drain_1 0 DC 1.0 AC 0
VS source_1 0 DC 0 AC 0
VB bulk_1 0 DC 0 AC 1
.TEMP 27
.PARAM AST_AC_FREQUENCY=1000000
.ALTER AST_CASE_264
VG gate_1 0 DC 0.85 AC 1
VD drain_1 0 DC 1.0 AC 0
VS source_1 0 DC 0 AC 0
VB bulk_1 0 DC 0 AC 0
.TEMP 27
.PARAM AST_AC_FREQUENCY=1000
.ALTER AST_CASE_265
VG gate_1 0 DC 0.85 AC 1
VD drain_1 0 DC 1.0 AC 0
VS source_1 0 DC 0 AC 0
VB bulk_1 0 DC 0 AC 0
.TEMP 27
.PARAM AST_AC_FREQUENCY=10000
.ALTER AST_CASE_266
VG gate_1 0 DC 0.85 AC 1
VD drain_1 0 DC 1.0 AC 0
VS source_1 0 DC 0 AC 0
VB bulk_1 0 DC 0 AC 0
.TEMP 27
.PARAM AST_AC_FREQUENCY=100000
.ALTER AST_CASE_267
VG gate_1 0 DC 0.85 AC 1
VD drain_1 0 DC 1.0 AC 0
VS source_1 0 DC 0 AC 0
VB bulk_1 0 DC 0 AC 0
.TEMP 27
.PARAM AST_AC_FREQUENCY=1000000
.ALTER AST_CASE_268
VG gate_1 0 DC 0.85 AC 1
VD drain_1 0 DC 1.0 AC 0
VS source_1 0 DC 0 AC 0
VB bulk_1 0 DC 0 AC 0
.TEMP 27
.PARAM AST_AC_FREQUENCY=1000000
.ALTER AST_CASE_269
VG gate_1 0 DC 0.85 AC 0
VD drain_1 0 DC 1.0 AC 1
VS source_1 0 DC 0 AC 0
VB bulk_1 0 DC 0 AC 0
.TEMP 27
.PARAM AST_AC_FREQUENCY=1000000
.ALTER AST_CASE_270
VG gate_1 0 DC 0.85 AC 0
VD drain_1 0 DC 1.0 AC 0
VS source_1 0 DC 0 AC 1
VB bulk_1 0 DC 0 AC 0
.TEMP 27
.PARAM AST_AC_FREQUENCY=1000000
.ALTER AST_CASE_271
VG gate_1 0 DC 0.85 AC 0
VD drain_1 0 DC 1.0 AC 0
VS source_1 0 DC 0 AC 0
VB bulk_1 0 DC 0 AC 1
.TEMP 27
.PARAM AST_AC_FREQUENCY=1000000
.ALTER AST_CASE_272
VG gate_1 0 DC 0.9 AC 1
VD drain_1 0 DC 1.0 AC 0
VS source_1 0 DC 0 AC 0
VB bulk_1 0 DC 0 AC 0
.TEMP 27
.PARAM AST_AC_FREQUENCY=1000
.ALTER AST_CASE_273
VG gate_1 0 DC 0.9 AC 1
VD drain_1 0 DC 1.0 AC 0
VS source_1 0 DC 0 AC 0
VB bulk_1 0 DC 0 AC 0
.TEMP 27
.PARAM AST_AC_FREQUENCY=10000
.ALTER AST_CASE_274
VG gate_1 0 DC 0.9 AC 1
VD drain_1 0 DC 1.0 AC 0
VS source_1 0 DC 0 AC 0
VB bulk_1 0 DC 0 AC 0
.TEMP 27
.PARAM AST_AC_FREQUENCY=100000
.ALTER AST_CASE_275
VG gate_1 0 DC 0.9 AC 1
VD drain_1 0 DC 1.0 AC 0
VS source_1 0 DC 0 AC 0
VB bulk_1 0 DC 0 AC 0
.TEMP 27
.PARAM AST_AC_FREQUENCY=1000000
.ALTER AST_CASE_276
VG gate_1 0 DC 0.9 AC 1
VD drain_1 0 DC 1.0 AC 0
VS source_1 0 DC 0 AC 0
VB bulk_1 0 DC 0 AC 0
.TEMP 27
.PARAM AST_AC_FREQUENCY=1000000
.ALTER AST_CASE_277
VG gate_1 0 DC 0.9 AC 0
VD drain_1 0 DC 1.0 AC 1
VS source_1 0 DC 0 AC 0
VB bulk_1 0 DC 0 AC 0
.TEMP 27
.PARAM AST_AC_FREQUENCY=1000000
.ALTER AST_CASE_278
VG gate_1 0 DC 0.9 AC 0
VD drain_1 0 DC 1.0 AC 0
VS source_1 0 DC 0 AC 1
VB bulk_1 0 DC 0 AC 0
.TEMP 27
.PARAM AST_AC_FREQUENCY=1000000
.ALTER AST_CASE_279
VG gate_1 0 DC 0.9 AC 0
VD drain_1 0 DC 1.0 AC 0
VS source_1 0 DC 0 AC 0
VB bulk_1 0 DC 0 AC 1
.TEMP 27
.PARAM AST_AC_FREQUENCY=1000000
.ALTER AST_CASE_280
VG gate_1 0 DC 0.95 AC 1
VD drain_1 0 DC 1.0 AC 0
VS source_1 0 DC 0 AC 0
VB bulk_1 0 DC 0 AC 0
.TEMP 27
.PARAM AST_AC_FREQUENCY=1000
.ALTER AST_CASE_281
VG gate_1 0 DC 0.95 AC 1
VD drain_1 0 DC 1.0 AC 0
VS source_1 0 DC 0 AC 0
VB bulk_1 0 DC 0 AC 0
.TEMP 27
.PARAM AST_AC_FREQUENCY=10000
.ALTER AST_CASE_282
VG gate_1 0 DC 0.95 AC 1
VD drain_1 0 DC 1.0 AC 0
VS source_1 0 DC 0 AC 0
VB bulk_1 0 DC 0 AC 0
.TEMP 27
.PARAM AST_AC_FREQUENCY=100000
.ALTER AST_CASE_283
VG gate_1 0 DC 0.95 AC 1
VD drain_1 0 DC 1.0 AC 0
VS source_1 0 DC 0 AC 0
VB bulk_1 0 DC 0 AC 0
.TEMP 27
.PARAM AST_AC_FREQUENCY=1000000
.ALTER AST_CASE_284
VG gate_1 0 DC 0.95 AC 1
VD drain_1 0 DC 1.0 AC 0
VS source_1 0 DC 0 AC 0
VB bulk_1 0 DC 0 AC 0
.TEMP 27
.PARAM AST_AC_FREQUENCY=1000000
.ALTER AST_CASE_285
VG gate_1 0 DC 0.95 AC 0
VD drain_1 0 DC 1.0 AC 1
VS source_1 0 DC 0 AC 0
VB bulk_1 0 DC 0 AC 0
.TEMP 27
.PARAM AST_AC_FREQUENCY=1000000
.ALTER AST_CASE_286
VG gate_1 0 DC 0.95 AC 0
VD drain_1 0 DC 1.0 AC 0
VS source_1 0 DC 0 AC 1
VB bulk_1 0 DC 0 AC 0
.TEMP 27
.PARAM AST_AC_FREQUENCY=1000000
.ALTER AST_CASE_287
VG gate_1 0 DC 0.95 AC 0
VD drain_1 0 DC 1.0 AC 0
VS source_1 0 DC 0 AC 0
VB bulk_1 0 DC 0 AC 1
.TEMP 27
.PARAM AST_AC_FREQUENCY=1000000
.ALTER AST_CASE_288
VG gate_1 0 DC 1 AC 1
VD drain_1 0 DC 1.0 AC 0
VS source_1 0 DC 0 AC 0
VB bulk_1 0 DC 0 AC 0
.TEMP 27
.PARAM AST_AC_FREQUENCY=1000
.ALTER AST_CASE_289
VG gate_1 0 DC 1 AC 1
VD drain_1 0 DC 1.0 AC 0
VS source_1 0 DC 0 AC 0
VB bulk_1 0 DC 0 AC 0
.TEMP 27
.PARAM AST_AC_FREQUENCY=10000
.ALTER AST_CASE_290
VG gate_1 0 DC 1 AC 1
VD drain_1 0 DC 1.0 AC 0
VS source_1 0 DC 0 AC 0
VB bulk_1 0 DC 0 AC 0
.TEMP 27
.PARAM AST_AC_FREQUENCY=100000
.ALTER AST_CASE_291
VG gate_1 0 DC 1 AC 1
VD drain_1 0 DC 1.0 AC 0
VS source_1 0 DC 0 AC 0
VB bulk_1 0 DC 0 AC 0
.TEMP 27
.PARAM AST_AC_FREQUENCY=1000000
.ALTER AST_CASE_292
VG gate_1 0 DC 1 AC 1
VD drain_1 0 DC 1.0 AC 0
VS source_1 0 DC 0 AC 0
VB bulk_1 0 DC 0 AC 0
.TEMP 27
.PARAM AST_AC_FREQUENCY=1000000
.ALTER AST_CASE_293
VG gate_1 0 DC 1 AC 0
VD drain_1 0 DC 1.0 AC 1
VS source_1 0 DC 0 AC 0
VB bulk_1 0 DC 0 AC 0
.TEMP 27
.PARAM AST_AC_FREQUENCY=1000000
.ALTER AST_CASE_294
VG gate_1 0 DC 1 AC 0
VD drain_1 0 DC 1.0 AC 0
VS source_1 0 DC 0 AC 1
VB bulk_1 0 DC 0 AC 0
.TEMP 27
.PARAM AST_AC_FREQUENCY=1000000
.ALTER AST_CASE_295
VG gate_1 0 DC 1 AC 0
VD drain_1 0 DC 1.0 AC 0
VS source_1 0 DC 0 AC 0
VB bulk_1 0 DC 0 AC 1
.TEMP 27
.PARAM AST_AC_FREQUENCY=1000000
.ALTER AST_CASE_296
VG gate_1 0 DC 1.05 AC 1
VD drain_1 0 DC 1.0 AC 0
VS source_1 0 DC 0 AC 0
VB bulk_1 0 DC 0 AC 0
.TEMP 27
.PARAM AST_AC_FREQUENCY=1000
.ALTER AST_CASE_297
VG gate_1 0 DC 1.05 AC 1
VD drain_1 0 DC 1.0 AC 0
VS source_1 0 DC 0 AC 0
VB bulk_1 0 DC 0 AC 0
.TEMP 27
.PARAM AST_AC_FREQUENCY=10000
.ALTER AST_CASE_298
VG gate_1 0 DC 1.05 AC 1
VD drain_1 0 DC 1.0 AC 0
VS source_1 0 DC 0 AC 0
VB bulk_1 0 DC 0 AC 0
.TEMP 27
.PARAM AST_AC_FREQUENCY=100000
.ALTER AST_CASE_299
VG gate_1 0 DC 1.05 AC 1
VD drain_1 0 DC 1.0 AC 0
VS source_1 0 DC 0 AC 0
VB bulk_1 0 DC 0 AC 0
.TEMP 27
.PARAM AST_AC_FREQUENCY=1000000
.ALTER AST_CASE_300
VG gate_1 0 DC 1.05 AC 1
VD drain_1 0 DC 1.0 AC 0
VS source_1 0 DC 0 AC 0
VB bulk_1 0 DC 0 AC 0
.TEMP 27
.PARAM AST_AC_FREQUENCY=1000000
.ALTER AST_CASE_301
VG gate_1 0 DC 1.05 AC 0
VD drain_1 0 DC 1.0 AC 1
VS source_1 0 DC 0 AC 0
VB bulk_1 0 DC 0 AC 0
.TEMP 27
.PARAM AST_AC_FREQUENCY=1000000
.ALTER AST_CASE_302
VG gate_1 0 DC 1.05 AC 0
VD drain_1 0 DC 1.0 AC 0
VS source_1 0 DC 0 AC 1
VB bulk_1 0 DC 0 AC 0
.TEMP 27
.PARAM AST_AC_FREQUENCY=1000000
.ALTER AST_CASE_303
VG gate_1 0 DC 1.05 AC 0
VD drain_1 0 DC 1.0 AC 0
VS source_1 0 DC 0 AC 0
VB bulk_1 0 DC 0 AC 1
.TEMP 27
.PARAM AST_AC_FREQUENCY=1000000
.ALTER AST_CASE_304
VG gate_1 0 DC 1.1 AC 1
VD drain_1 0 DC 1.0 AC 0
VS source_1 0 DC 0 AC 0
VB bulk_1 0 DC 0 AC 0
.TEMP 27
.PARAM AST_AC_FREQUENCY=1000
.ALTER AST_CASE_305
VG gate_1 0 DC 1.1 AC 1
VD drain_1 0 DC 1.0 AC 0
VS source_1 0 DC 0 AC 0
VB bulk_1 0 DC 0 AC 0
.TEMP 27
.PARAM AST_AC_FREQUENCY=10000
.ALTER AST_CASE_306
VG gate_1 0 DC 1.1 AC 1
VD drain_1 0 DC 1.0 AC 0
VS source_1 0 DC 0 AC 0
VB bulk_1 0 DC 0 AC 0
.TEMP 27
.PARAM AST_AC_FREQUENCY=100000
.ALTER AST_CASE_307
VG gate_1 0 DC 1.1 AC 1
VD drain_1 0 DC 1.0 AC 0
VS source_1 0 DC 0 AC 0
VB bulk_1 0 DC 0 AC 0
.TEMP 27
.PARAM AST_AC_FREQUENCY=1000000
.ALTER AST_CASE_308
VG gate_1 0 DC 1.1 AC 1
VD drain_1 0 DC 1.0 AC 0
VS source_1 0 DC 0 AC 0
VB bulk_1 0 DC 0 AC 0
.TEMP 27
.PARAM AST_AC_FREQUENCY=1000000
.ALTER AST_CASE_309
VG gate_1 0 DC 1.1 AC 0
VD drain_1 0 DC 1.0 AC 1
VS source_1 0 DC 0 AC 0
VB bulk_1 0 DC 0 AC 0
.TEMP 27
.PARAM AST_AC_FREQUENCY=1000000
.ALTER AST_CASE_310
VG gate_1 0 DC 1.1 AC 0
VD drain_1 0 DC 1.0 AC 0
VS source_1 0 DC 0 AC 1
VB bulk_1 0 DC 0 AC 0
.TEMP 27
.PARAM AST_AC_FREQUENCY=1000000
.ALTER AST_CASE_311
VG gate_1 0 DC 1.1 AC 0
VD drain_1 0 DC 1.0 AC 0
VS source_1 0 DC 0 AC 0
VB bulk_1 0 DC 0 AC 1
.TEMP 27
.PARAM AST_AC_FREQUENCY=1000000
.ALTER AST_CASE_312
VG gate_1 0 DC 1.15 AC 1
VD drain_1 0 DC 1.0 AC 0
VS source_1 0 DC 0 AC 0
VB bulk_1 0 DC 0 AC 0
.TEMP 27
.PARAM AST_AC_FREQUENCY=1000
.ALTER AST_CASE_313
VG gate_1 0 DC 1.15 AC 1
VD drain_1 0 DC 1.0 AC 0
VS source_1 0 DC 0 AC 0
VB bulk_1 0 DC 0 AC 0
.TEMP 27
.PARAM AST_AC_FREQUENCY=10000
.ALTER AST_CASE_314
VG gate_1 0 DC 1.15 AC 1
VD drain_1 0 DC 1.0 AC 0
VS source_1 0 DC 0 AC 0
VB bulk_1 0 DC 0 AC 0
.TEMP 27
.PARAM AST_AC_FREQUENCY=100000
.ALTER AST_CASE_315
VG gate_1 0 DC 1.15 AC 1
VD drain_1 0 DC 1.0 AC 0
VS source_1 0 DC 0 AC 0
VB bulk_1 0 DC 0 AC 0
.TEMP 27
.PARAM AST_AC_FREQUENCY=1000000
.ALTER AST_CASE_316
VG gate_1 0 DC 1.15 AC 1
VD drain_1 0 DC 1.0 AC 0
VS source_1 0 DC 0 AC 0
VB bulk_1 0 DC 0 AC 0
.TEMP 27
.PARAM AST_AC_FREQUENCY=1000000
.ALTER AST_CASE_317
VG gate_1 0 DC 1.15 AC 0
VD drain_1 0 DC 1.0 AC 1
VS source_1 0 DC 0 AC 0
VB bulk_1 0 DC 0 AC 0
.TEMP 27
.PARAM AST_AC_FREQUENCY=1000000
.ALTER AST_CASE_318
VG gate_1 0 DC 1.15 AC 0
VD drain_1 0 DC 1.0 AC 0
VS source_1 0 DC 0 AC 1
VB bulk_1 0 DC 0 AC 0
.TEMP 27
.PARAM AST_AC_FREQUENCY=1000000
.ALTER AST_CASE_319
VG gate_1 0 DC 1.15 AC 0
VD drain_1 0 DC 1.0 AC 0
VS source_1 0 DC 0 AC 0
VB bulk_1 0 DC 0 AC 1
.TEMP 27
.PARAM AST_AC_FREQUENCY=1000000
.ALTER AST_CASE_320
VG gate_1 0 DC 1.2 AC 1
VD drain_1 0 DC 1.0 AC 0
VS source_1 0 DC 0 AC 0
VB bulk_1 0 DC 0 AC 0
.TEMP 27
.PARAM AST_AC_FREQUENCY=1000
.ALTER AST_CASE_321
VG gate_1 0 DC 1.2 AC 1
VD drain_1 0 DC 1.0 AC 0
VS source_1 0 DC 0 AC 0
VB bulk_1 0 DC 0 AC 0
.TEMP 27
.PARAM AST_AC_FREQUENCY=10000
.ALTER AST_CASE_322
VG gate_1 0 DC 1.2 AC 1
VD drain_1 0 DC 1.0 AC 0
VS source_1 0 DC 0 AC 0
VB bulk_1 0 DC 0 AC 0
.TEMP 27
.PARAM AST_AC_FREQUENCY=100000
.ALTER AST_CASE_323
VG gate_1 0 DC 1.2 AC 1
VD drain_1 0 DC 1.0 AC 0
VS source_1 0 DC 0 AC 0
VB bulk_1 0 DC 0 AC 0
.TEMP 27
.PARAM AST_AC_FREQUENCY=1000000
.ALTER AST_CASE_324
VG gate_1 0 DC 1.2 AC 1
VD drain_1 0 DC 1.0 AC 0
VS source_1 0 DC 0 AC 0
VB bulk_1 0 DC 0 AC 0
.TEMP 27
.PARAM AST_AC_FREQUENCY=1000000
.ALTER AST_CASE_325
VG gate_1 0 DC 1.2 AC 0
VD drain_1 0 DC 1.0 AC 1
VS source_1 0 DC 0 AC 0
VB bulk_1 0 DC 0 AC 0
.TEMP 27
.PARAM AST_AC_FREQUENCY=1000000
.ALTER AST_CASE_326
VG gate_1 0 DC 1.2 AC 0
VD drain_1 0 DC 1.0 AC 0
VS source_1 0 DC 0 AC 1
VB bulk_1 0 DC 0 AC 0
.TEMP 27
.PARAM AST_AC_FREQUENCY=1000000
.ALTER AST_CASE_327
VG gate_1 0 DC 1.2 AC 0
VD drain_1 0 DC 1.0 AC 0
VS source_1 0 DC 0 AC 0
VB bulk_1 0 DC 0 AC 1
.TEMP 27
.PARAM AST_AC_FREQUENCY=1000000
.ALTER AST_CASE_328
VG gate_1 0 DC 1.2 AC 1
VD drain_1 0 DC 1.0 AC 0
VS source_1 0 DC 0 AC 0
VB bulk_1 0 DC 0 AC 0
VGS gate_in2 0 DC 0.8 AC 1
VDS drain_in2 0 DC 1.0 AC 0
.TEMP 27
.PARAM AST_AC_FREQUENCY=1000000
.ALTER AST_CASE_329
VG gate_1 0 DC 1.2 AC 1
VD drain_1 0 DC 1.0 AC 0
VS source_1 0 DC 0 AC 0
VB bulk_1 0 DC 0 AC 0
VGS gate_in2 0 DC 0.8 AC 0
VDS drain_in2 0 DC 1.0 AC 1
.TEMP 27
.PARAM AST_AC_FREQUENCY=1000000
.ALTER AST_CASE_330
VG gate_1 0 DC 1.2 AC 1
VD drain_1 0 DC 1.0 AC 0
VS source_1 0 DC 0 AC 0
VB bulk_1 0 DC 0 AC 0
VGS gate_in2 0 DC 0.8 AC 1
VDS drain_in2 0 DC 1.0 AC 0
.TEMP 27
.PARAM AST_AC_FREQUENCY=10000000
.ALTER AST_CASE_331
VG gate_1 0 DC 1.2 AC 1
VD drain_1 0 DC 1.0 AC 0
VS source_1 0 DC 0 AC 0
VB bulk_1 0 DC 0 AC 0
VGS gate_in2 0 DC 0.8 AC 0
VDS drain_in2 0 DC 1.0 AC 1
.TEMP 27
.PARAM AST_AC_FREQUENCY=10000000
.ALTER AST_CASE_332
VG gate_1 0 DC 1.2 AC 1
VD drain_1 0 DC 1.0 AC 0
VS source_1 0 DC 0 AC 0
VB bulk_1 0 DC 0 AC 0
VGS gate_in2 0 DC 0.8 AC 1
VDS drain_in2 0 DC 1.0 AC 0
.TEMP 27
.PARAM AST_AC_FREQUENCY=100000000
.ALTER AST_CASE_333
VG gate_1 0 DC 1.2 AC 1
VD drain_1 0 DC 1.0 AC 0
VS source_1 0 DC 0 AC 0
VB bulk_1 0 DC 0 AC 0
VGS gate_in2 0 DC 0.8 AC 0
VDS drain_in2 0 DC 1.0 AC 1
.TEMP 27
.PARAM AST_AC_FREQUENCY=100000000
.ALTER AST_CASE_334
VG gate_1 0 DC 1.2 AC 1
VD drain_1 0 DC 1.0 AC 0
VS source_1 0 DC 0 AC 0
VB bulk_1 0 DC 0 AC 0
VGS gate_in2 0 DC 0.8 AC 1
VDS drain_in2 0 DC 1.0 AC 0
.TEMP 27
.PARAM AST_AC_FREQUENCY=1000000000
.ALTER AST_CASE_335
VG gate_1 0 DC 1.2 AC 1
VD drain_1 0 DC 1.0 AC 0
VS source_1 0 DC 0 AC 0
VB bulk_1 0 DC 0 AC 0
VGS gate_in2 0 DC 0.8 AC 0
VDS drain_in2 0 DC 1.0 AC 1
.TEMP 27
.PARAM AST_AC_FREQUENCY=1000000000
.ALTER AST_CASE_336
VG gate_1 0 DC 0.8 AC 1
VD drain_1 0 DC 1.0 AC 0
VS source_1 0 DC 0 AC 0
VB bulk_1 0 DC 0 AC 0
VGS gate_in2 0 DC 0.8 AC 0
VDS drain_in2 0 DC 1.0 AC 1
.TEMP 27
.PARAM AST_AC_FREQUENCY=10000000
.ALTER AST_CASE_337
VG gate_1 0 DC 0.8 AC 1
VD drain_1 0 DC 1.0 AC 0
VS source_1 0 DC 0 AC 0
VB bulk_1 0 DC 0 AC 0
VGS gate_in2 0 DC 0.8 AC 0
VDS drain_in2 0 DC 1.0 AC 1
.TEMP 27
.PARAM AST_AC_FREQUENCY=100000000
.ALTER AST_CASE_338
VG gate_1 0 DC 0.8 AC 1
VD drain_1 0 DC 1.0 AC 0
VS source_1 0 DC 0 AC 0
VB bulk_1 0 DC 0 AC 0
VGS gate_in2 0 DC 0.8 AC 0
VDS drain_in2 0 DC 1.0 AC 1
.TEMP 27
.PARAM AST_AC_FREQUENCY=1000000000
.ALTER AST_CASE_339
VG gate_1 0 DC 0.8 AC 1
VD drain_1 0 DC 1.0 AC 0
VS source_1 0 DC 0 AC 0
VB bulk_1 0 DC 0 AC 0
VGS gate_in2 0 DC 0.8 AC 0
VDS drain_in2 0 DC 1.0 AC 1
.TEMP 27
.PARAM AST_AC_FREQUENCY=10000000000
.ALTER AST_CASE_340
VG gate_1 0 DC 0.8 AC 1
VD drain_1 0 DC 1.0 AC 0
VS source_1 0 DC 0 AC 0
VB bulk_1 0 DC 0 AC 0
VGS gate_in2 0 DC 0.8 AC 0
VDS drain_in2 0 DC 1.0 AC 1
.TEMP 27
.tran 1e-11 5e-09
.END
