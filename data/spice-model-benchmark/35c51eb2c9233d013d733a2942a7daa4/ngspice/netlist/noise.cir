* MOSFET Noise Analysis Simulation
* Benchmark contract: mosfet-fixed-native-v1
.option temp=27 tnom=27
.option gmin=1e-15
.option reltol=1e-8
.option abstol=1e-12
.option chgtol=1e-15
.option method=gear
.option TEMP=27
.option TNOM=27
.option TEMPSCALE=1.0

* Fixed-fixture model binding (path and card names are the only substitutions)
.inc '/home/duhaochen/pipeline_sky130_mos/benchmark-inputs/35c51eb2c9233d013d733a2942a7daa4/ngspice.lib'

* Fixed common-source output-noise topology.  Gload is an ideal noiseless
* 1 kohm transimpedance load: it exposes DUT current noise as output voltage
* without adding a resistor's own thermal-noise floor.
Vdd_noise noise_vdd 0 DC 0.3
Vin_noise gate_noise 0 DC 0.3 AC 1
Gload_noise noise_vdd drain_noise noise_vdd drain_noise 1m
M_noise drain_noise gate_noise 0 0 __benchmark_selected_nmos L=1u W=10u

* Control block
.control
set filetype=ascii
set wr_vecnames
set wr_singlescale
set wr_formatted
set numdgt=15

echo "Starting noise analysis simulations"

* Thermal Noise Analysis
echo "Thermal Noise Analysis"
* Setup bias conditions for thermal noise analysis

* First bias point (0.3, 0.3)
alter Vin_noise = 0.3
alter Vdd_noise = 0.3
noise v(drain_noise) Vin_noise dec 20 1 1G
setplot noise1
let thermal_noise = onoise_spectrum
let freq = frequency
write ./thermal_noise_vgs0.3_vds0.3.txt freq thermal_noise

* Second bias point (0.3, 0.6)
alter Vin_noise = 0.3
alter Vdd_noise = 0.6
noise v(drain_noise) Vin_noise dec 20 1 1G
setplot noise3
let thermal_noise = onoise_spectrum
let freq = frequency
write ./thermal_noise_vgs0.3_vds0.6.txt freq thermal_noise

* Third bias point (0.3, 0.9)
alter Vin_noise = 0.3
alter Vdd_noise = 0.9
noise v(drain_noise) Vin_noise dec 20 1 1G
setplot noise5
let thermal_noise = onoise_spectrum
let freq = frequency
write ./thermal_noise_vgs0.3_vds0.9.txt freq thermal_noise

* Fourth bias point (0.3, 1.2)
alter Vin_noise = 0.3
alter Vdd_noise = 1.2
noise v(drain_noise) Vin_noise dec 20 1 1G
setplot noise7
let thermal_noise = onoise_spectrum
let freq = frequency
write ./thermal_noise_vgs0.3_vds1.2.txt freq thermal_noise

* Fifth bias point (0.6, 0.3)
alter Vin_noise = 0.6
alter Vdd_noise = 0.3
noise v(drain_noise) Vin_noise dec 20 1 1G
setplot noise9
let thermal_noise = onoise_spectrum
let freq = frequency
write ./thermal_noise_vgs0.6_vds0.3.txt freq thermal_noise

* Sixth bias point (0.6, 0.6)
alter Vin_noise = 0.6
alter Vdd_noise = 0.6
noise v(drain_noise) Vin_noise dec 20 1 1G
setplot noise11
let thermal_noise = onoise_spectrum
let freq = frequency
write ./thermal_noise_vgs0.6_vds0.6.txt freq thermal_noise

* Low-frequency total output-noise analysis.  A 1/f slope is only expected
* when the bound model actually supplies flicker-noise parameters.
echo "Low-frequency total output-noise analysis"
alter Vin_noise = 0.6
alter Vdd_noise = 0.6
noise v(drain_noise) Vin_noise dec 20 0.1 1MEG
setplot noise13
let flicker_noise = onoise_spectrum
let freq = frequency
write ./flicker_noise.txt freq flicker_noise

* High-frequency total output-noise analysis.
echo "High-frequency total output-noise analysis"
alter Vin_noise = 0.9
alter Vdd_noise = 1.2
noise v(drain_noise) Vin_noise dec 20 1 1G
setplot noise15
let shot_noise = onoise_spectrum
let freq = frequency
write ./shot_noise.txt freq shot_noise

* Temperature-Dependent Noise Analysis
echo "Temperature-Dependent Noise Analysis"
* Run noise analysis at different temperatures

* First temperature -40°C
option temp = -40
* Set consistent bias point for temperature dependency analysis
alter Vin_noise = 0.6
alter Vdd_noise = 0.6
noise v(drain_noise) Vin_noise dec 20 1 1G
setplot noise17
let temp_noise = onoise_spectrum
let freq = frequency
write ./noise_temp-40.txt freq temp_noise

* Second temperature 0°C
option temp = 0
* Set consistent bias point for temperature dependency analysis
alter Vin_noise = 0.6
alter Vdd_noise = 0.6
noise v(drain_noise) Vin_noise dec 20 1 1G
setplot noise19
let temp_noise = onoise_spectrum
let freq = frequency
write ./noise_temp0.txt freq temp_noise

* Third temperature 27°C
option temp = 27
* Set consistent bias point for temperature dependency analysis
alter Vin_noise = 0.6
alter Vdd_noise = 0.6
noise v(drain_noise) Vin_noise dec 20 1 1G
setplot noise21
let temp_noise = onoise_spectrum
let freq = frequency
write ./noise_temp27.txt freq temp_noise

* Fourth temperature 50°C
option temp = 50
* Set consistent bias point for temperature dependency analysis
alter Vin_noise = 0.6
alter Vdd_noise = 0.6
noise v(drain_noise) Vin_noise dec 20 1 1G
setplot noise23
let temp_noise = onoise_spectrum
let freq = frequency
write ./noise_temp50.txt freq temp_noise

* Fifth temperature 100°C
option temp = 100
* Set consistent bias point for temperature dependency analysis
alter Vin_noise = 0.6
alter Vdd_noise = 0.6
noise v(drain_noise) Vin_noise dec 20 1 1G
setplot noise25
let temp_noise = onoise_spectrum
let freq = frequency
write ./noise_temp100.txt freq temp_noise

* Sixth temperature 150°C
option temp = 150
* Set consistent bias point for temperature dependency analysis
alter Vin_noise = 0.6
alter Vdd_noise = 0.6
noise v(drain_noise) Vin_noise dec 20 1 1G
setplot noise27
let temp_noise = onoise_spectrum
let freq = frequency
write ./noise_temp150.txt freq temp_noise

echo "Noise analysis simulations completed"
quit
.endc

.end
