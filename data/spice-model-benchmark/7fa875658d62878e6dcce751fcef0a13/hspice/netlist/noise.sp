* Fixed native HSPICE noise benchmark fixture.
* Benchmark contract: mosfet-fixed-native-v1
* All cases use the same common-source topology.  GLOAD is an ideal noiseless
* 1 kohm transimpedance load, so the reported spectrum belongs to the DUT.
.TITLE Fixed native MOSFET noise benchmark
.OPTION POST=1 BRIEF NOMOD INGOLD=2 NUMDGT=10
.OPTION TNOM=27 GMIN=1e-15 RELTOL=1e-6 ABSTOL=1e-12
.INC '/home/duhaochen/pipeline_sky130_mos/benchmark-inputs/7fa875658d62878e6dcce751fcef0a13/hspice.lib'

.PARAM VGS_BIAS=0.3 VDS_BIAS=0.3
.PARAM NOISE_START=1 NOISE_STOP=1gig
VDD noise_vdd 0 DC=VDS_BIAS
VIN noise_gate 0 DC=VGS_BIAS AC=1
GLOAD noise_vdd noise_drain noise_vdd noise_drain 1m
M_NOISE noise_drain noise_gate 0 0 __benchmark_selected_pmos L=1u W=10u
.PRINT NOISE ONOISE INOISE
.AC DEC 20 NOISE_START NOISE_STOP
.NOISE V(noise_drain) VIN 1

.ALTER FIXTURE_CASE_0
.TEMP 27
.PARAM VGS_BIAS=0.3 VDS_BIAS=0.3
.PARAM NOISE_START=1 NOISE_STOP=1gig
.ALTER FIXTURE_CASE_1
.TEMP 27
.PARAM VGS_BIAS=0.3 VDS_BIAS=0.6
.PARAM NOISE_START=1 NOISE_STOP=1gig
.ALTER FIXTURE_CASE_2
.TEMP 27
.PARAM VGS_BIAS=0.3 VDS_BIAS=0.9
.PARAM NOISE_START=1 NOISE_STOP=1gig
.ALTER FIXTURE_CASE_3
.TEMP 27
.PARAM VGS_BIAS=0.3 VDS_BIAS=1.2
.PARAM NOISE_START=1 NOISE_STOP=1gig
.ALTER FIXTURE_CASE_4
.TEMP 27
.PARAM VGS_BIAS=0.6 VDS_BIAS=0.3
.PARAM NOISE_START=1 NOISE_STOP=1gig
.ALTER FIXTURE_CASE_5
.TEMP 27
.PARAM VGS_BIAS=0.6 VDS_BIAS=0.6
.PARAM NOISE_START=1 NOISE_STOP=1gig

* Low-frequency total output-noise case (contains 1/f when the model has it).
.ALTER FIXTURE_CASE_6
.TEMP 27
.PARAM VGS_BIAS=0.6 VDS_BIAS=0.6
.PARAM NOISE_START=0.1 NOISE_STOP=1meg

* High-frequency total output-noise case.
.ALTER FIXTURE_CASE_7
.TEMP 27
.PARAM VGS_BIAS=0.9 VDS_BIAS=1.2
.PARAM NOISE_START=1 NOISE_STOP=1gig

.ALTER FIXTURE_CASE_8
.TEMP -40
.PARAM VGS_BIAS=0.6 VDS_BIAS=0.6
.PARAM NOISE_START=1 NOISE_STOP=1gig
.ALTER FIXTURE_CASE_9
.TEMP 0
.PARAM VGS_BIAS=0.6 VDS_BIAS=0.6
.PARAM NOISE_START=1 NOISE_STOP=1gig
.ALTER FIXTURE_CASE_10
.TEMP 27
.PARAM VGS_BIAS=0.6 VDS_BIAS=0.6
.PARAM NOISE_START=1 NOISE_STOP=1gig
.ALTER FIXTURE_CASE_11
.TEMP 50
.PARAM VGS_BIAS=0.6 VDS_BIAS=0.6
.PARAM NOISE_START=1 NOISE_STOP=1gig
.ALTER FIXTURE_CASE_12
.TEMP 100
.PARAM VGS_BIAS=0.6 VDS_BIAS=0.6
.PARAM NOISE_START=1 NOISE_STOP=1gig
.ALTER FIXTURE_CASE_13
.TEMP 150
.PARAM VGS_BIAS=0.6 VDS_BIAS=0.6
.PARAM NOISE_START=1 NOISE_STOP=1gig
.END
